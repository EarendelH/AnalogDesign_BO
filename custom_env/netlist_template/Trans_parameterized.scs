// Design: LDO_SSF/tb_LDO_Trans
simulator lang=spectre
global 0
parameters CAP_CMP RES_CMP IBN_EA IBN_REF I_MAX=200m ILOAD=0 VDD=2 w_M1 l_M1 nf_M1 w_M2 l_M2 nf_M2 w_M25 l_M25 nf_M25 w_M18 l_M18 nf_M18 w_M17 l_M17 nf_M17 w_M16 l_M16 nf_M16 w_M7 l_M7 nf_M7 w_M6 l_M6 nf_M6 w_M20 l_M20 nf_M20 w_M12 l_M12 nf_M12 w_M8 l_M8 nf_M8 w_M13 l_M13 nf_M13 w_M4 l_M4 nf_M4 w_M23 l_M23 nf_M23 w_M24 l_M24 nf_M24 w_M19 l_M19 nf_M19 w_M15 l_M15 nf_M15 w_M14 l_M14 nf_M14 w_M26 l_M26 nf_M26 w_M9 l_M9 nf_M9 w_M5 l_M5 nf_M5 w_M3 l_M3 nf_M3 w_M21 l_M21 nf_M21 w_M11 l_M11 nf_M11 w_M10 l_M10 nf_M10 w_M22 l_M22 nf_M22 w_M29 l_M29 nf_M29 w_M35 l_M35 nf_M35 w_M30 l_M30 nf_M30 w_M36 l_M36 nf_M36 w_M27 l_M27 nf_M27 w_M31 l_M31 nf_M31 w_M33 l_M33 nf_M33 w_M28 l_M28 nf_M28 w_M32 l_M32 nf_M32 w_M34 l_M34 nf_M34 w_M0 l_M0 nf_M0
include "/data/PDK/pdk_installed/tsmc180bcd_g2/pdk/pdk_1p6m_2/tsmc18/../models/spectre/c018bcd_gen2_v1d6_usage.scs" section=pre_simu
include "/data/PDK/pdk_installed/tsmc180bcd_g2/pdk/pdk_1p6m_2/tsmc18/../models/spectre/c018bcd_gen2_v1d6_usage.scs" section=tt_lib
// LDO_SSF/EA_Core/schematic
subckt EA_Core IBN_EA IBP_EA_2U_1 IBP_EA_2U_2 VDD VEA VFB VG VREF VSS
    M1 (net125 VFB net66 net66) nch_mac l=l_M1 w=w_M1 m=6 nf=nf_M1
    M2 (net128 VREF net66 net66) nch_mac l=l_M2 w=w_M2 m=6 nf=nf_M2
    M25 (VG IBP_BUF2 VSS VSS) nch_mac l=l_M25 w=w_M25 m=1 nf=nf_M25
    M18 (VEA VBN_CAS net127 VSS) nch_mac l=l_M18 w=w_M18 m=2 nf=nf_M18
    M17 (net126 VBN_CAS net124 VSS) nch_mac l=l_M17 w=w_M17 m=2 nf=nf_M17
    M16 (IBN_EA IBN_EA VSS VSS) nch_mac l=l_M16 w=w_M16 m=5 nf=nf_M16
    M7 (net127 net126 VSS VSS) nch_mac l=l_M7 w=w_M7 m=1 nf=nf_M7
    M6 (net124 net126 VSS VSS) nch_mac l=l_M6 w=w_M6 m=1 nf=nf_M6
    M20 (VBN_CAS VBN_CAS net098 VSS) nch_mac l=l_M20 w=w_M20 m=1 nf=nf_M20
    M12 (IBP_BUF2 IBN_EA VSS VSS) nch_mac l=l_M12 w=w_M12 m=1 nf=nf_M12
    M8 (IBP_BUF1 IBN_EA VSS VSS) nch_mac l=l_M8 w=w_M8 m=1 nf=nf_M8
    M13 (net66 IBN_EA VSS VSS) nch_mac l=l_M13 w=w_M13 m=5 nf=nf_M13
    M4 (VBP_TAIL IBN_EA VSS VSS) nch_mac l=l_M4 w=w_M4 m=1 nf=nf_M4
    M23 (net098 VBN_CAS VSS VSS) nch_mac l=l_M23 w=w_M23 m=1 nf=nf_M23
    M24 (VEA IBP_EA_2U_2 net128 VDD) pch_mac l=l_M24 w=w_M24 m=2 nf=nf_M24
    M19 (net126 IBP_EA_2U_2 net125 VDD) pch_mac l=l_M19 w=w_M19 m=2 nf=nf_M19
    M15 (VBP_TAIL VBP_TAIL VDD VDD) pch_mac l=l_M15 w=w_M15 m=1 nf=nf_M15
    M14 (net125 VBP_TAIL VDD VDD) pch_mac l=l_M14 w=w_M14 m=3 nf=nf_M14
    M26 (net128 VBP_TAIL VDD VDD) pch_mac l=l_M26 w=w_M26 m=3 nf=nf_M26
    M9 (VG IBP_BUF1 VDD VDD) pch_mac l=l_M9 w=w_M9 m=2 nf=nf_M9
    M5 (IBP_BUF1 IBP_BUF1 VDD VDD) pch_mac l=l_M5 w=w_M5 m=1 nf=nf_M5
    M3 (IBP_BUF2 VEA VG VDD) pch_mac l=l_M3 w=w_M3 m=4 nf=nf_M3
    M21 (IBP_EA_2U_1 IBP_EA_2U_1 VDD VDD) pch_mac l=l_M21 w=w_M21 m=1 nf=nf_M21
    M11 (IBP_EA_2U_2 IBP_EA_2U_2 net091 VDD) pch_mac l=l_M11 w=w_M11 m=1 nf=nf_M11
    M10 (net091 IBP_EA_2U_2 VDD VDD) pch_mac l=l_M10 w=w_M10 m=1 nf=nf_M10
    M22 (VBN_CAS IBP_EA_2U_1 VDD VDD) pch_mac l=l_M22 w=w_M22 m=3 nf=nf_M22
ends EA_Core
// LDO_SSF/EA_Bias/schematic
subckt EA_Bias IBN_REF IBP_EA_2U_1 IBP_EA_2U_2 VDD VSS
    M29 (IBP_EA_2U_1 net016 net028 VSS) nch_mac l=l_M29 w=w_M29 m=1 nf=nf_M29
    M35 (net016 net016 net031 VSS) nch_mac l=l_M35 w=w_M35 m=1 nf=nf_M35
    M30 (net028 IBN_REF VSS VSS) nch_mac l=l_M30 w=w_M30 m=1 nf=nf_M30
    M36 (net069 IBN_REF VSS VSS) nch_mac l=l_M36 w=w_M36 m=1 nf=nf_M36
    M27 (IBN_REF IBN_REF VSS VSS) nch_mac l=l_M27 w=w_M27 m=1 nf=nf_M27
    M31 (net031 net016 VSS VSS) nch_mac l=l_M31 w=w_M31 m=1 nf=nf_M31
    M33 (IBP_EA_2U_2 net016 net030 VSS) nch_mac l=l_M33 w=w_M33 m=1 nf=nf_M33
    M28 (net030 IBN_REF VSS VSS) nch_mac l=l_M28 w=w_M28 m=1 nf=nf_M28
    M32 (net016 net069 VDD VDD) pch_mac l=l_M32 w=w_M32 m=2 nf=nf_M32
    M34 (net069 net069 VDD VDD) pch_mac l=l_M34 w=w_M34 m=1 nf=nf_M34
ends EA_Bias
// LDO_SSF/tb_LDO_Trans/schematic
I8 (IBN_EA IBP_EA_2U_1 IBP_EA_2U_2 VDD VEA VOUT VG VREF VSS) EA_Core
VIN2 (VDD 0) vsource dc=VDD type=dc
V3 (VSS 0) vsource dc=0 type=dc
V2 (VREF VSS) vsource dc=1.2 type=dc
I12 (VREF IBN_REF) isource dc=IBN_REF type=dc
I4 (VREF IBN_EA) isource dc=IBN_EA type=dc
C1 (VEA net016) capacitor c=CAP_CMP
C0 (VOUT VSS) capacitor c=10n
R0 (net016 VOUT) resistor r=RES_CMP
R1 (VSS VOUT) resistor r=100K
I9 (IBN_REF IBP_EA_2U_1 IBP_EA_2U_2 VDD VSS) EA_Bias
I19 (VOUT VSS) isource type=pulse val0=500.0u val1=I_MAX period=20u delay=2u rise=1n fall=1n width=10u
M0 (VOUT VG VDD VDD) pch_mac l=l_M0 w=w_M0 m=1 nf=nf_M0
simulatorOptions options temp=27
tran tran stop=20u errpreset=conservative
