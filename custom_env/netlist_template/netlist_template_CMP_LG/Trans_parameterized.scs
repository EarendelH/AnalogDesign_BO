// Design: CMP_LG/tb_CMP_Trans
simulator lang=spectre
global 0
parameters vdd=5 ILOAD w_M0_per_finger l_M0 nf_M0 w_M1_per_finger l_M1 nf_M1 w_M3_per_finger l_M3 nf_M3 w_M4_per_finger l_M4 nf_M4 w_M5_per_finger l_M5 nf_M5 w_M6_per_finger l_M6 nf_M6 w_M7_per_finger l_M7 nf_M7 w_M8_per_finger l_M8 nf_M8 w_M9_per_finger l_M9 nf_M9 w_M10_per_finger l_M10 nf_M10 w_M12_per_finger l_M12 nf_M12 w_M13_per_finger l_M13 nf_M13 w_M14_per_finger l_M14 nf_M14 w_M15_per_finger l_M15 nf_M15 w_M16_per_finger l_M16 nf_M16 w_M17_per_finger l_M17 nf_M17 w_M18_per_finger l_M18 nf_M18 w_M19_per_finger l_M19 nf_M19 w_M20_per_finger l_M20 nf_M20 w_M21_per_finger l_M21 nf_M21 w_M22_per_finger l_M22 nf_M22 w_M23_per_finger l_M23 nf_M23 w_M25_per_finger l_M25 nf_M25 w_M26_per_finger l_M26 nf_M26 w_M27_per_finger l_M27 nf_M27 w_M30_per_finger l_M30 nf_M30 w_M32_per_finger l_M32 nf_M32
include "/data/codesign/tyb/wuhan/dbht180xh/pdk/pdk_1p5m/181abd18ba/../models/Spectre_lib/181aBD18BA_Rev3p7p0.scs" section=norflag_svt018
include "/data/codesign/tyb/wuhan/dbht180xh/pdk/pdk_1p5m/181abd18ba/../models/Spectre_lib/181aBD18BA_Rev3p7p0.scs" section=tt_svt018
include "/data/codesign/tyb/wuhan/dbht180xh/pdk/pdk_1p5m/181abd18ba/../models/Spectre_lib/181aBD18BA_Rev3p7p0.scs" section=norflag_svt050
include "/data/codesign/tyb/wuhan/dbht180xh/pdk/pdk_1p5m/181abd18ba/../models/Spectre_lib/181aBD18BA_Rev3p7p0.scs" section=tt_svt050
include "/data/codesign/tyb/wuhan/dbht180xh/pdk/pdk_1p5m/181abd18ba/../models/Spectre_lib/181aBD18BA_Rev3p7p0.scs" section=norflag_svt060
include "/data/codesign/tyb/wuhan/dbht180xh/pdk/pdk_1p5m/181abd18ba/../models/Spectre_lib/181aBD18BA_Rev3p7p0.scs" section=tt_svt060
include "/data/codesign/tyb/wuhan/dbht180xh/pdk/pdk_1p5m/181abd18ba/../models/Spectre_lib/181aBD18BA_Rev3p7p0.scs" section=norflag_lvt018
include "/data/codesign/tyb/wuhan/dbht180xh/pdk/pdk_1p5m/181abd18ba/../models/Spectre_lib/181aBD18BA_Rev3p7p0.scs" section=tt_lvt018
include "/data/codesign/tyb/wuhan/dbht180xh/pdk/pdk_1p5m/181abd18ba/../models/Spectre_lib/181aBD18BA_Rev3p7p0.scs" section=norflag_lvt050
include "/data/codesign/tyb/wuhan/dbht180xh/pdk/pdk_1p5m/181abd18ba/../models/Spectre_lib/181aBD18BA_Rev3p7p0.scs" section=tt_lvt050
include "/data/codesign/tyb/wuhan/dbht180xh/pdk/pdk_1p5m/181abd18ba/../models/Spectre_lib/181aBD18BA_Rev3p7p0.scs" section=norflag_hvt018
include "/data/codesign/tyb/wuhan/dbht180xh/pdk/pdk_1p5m/181abd18ba/../models/Spectre_lib/181aBD18BA_Rev3p7p0.scs" section=tt_hvt018
include "/data/codesign/tyb/wuhan/dbht180xh/pdk/pdk_1p5m/181abd18ba/../models/Spectre_lib/181aBD18BA_Rev3p7p0.scs" section=norflag_dvt050
include "/data/codesign/tyb/wuhan/dbht180xh/pdk/pdk_1p5m/181abd18ba/../models/Spectre_lib/181aBD18BA_Rev3p7p0.scs" section=tt_dvt050
include "/data/codesign/tyb/wuhan/dbht180xh/pdk/pdk_1p5m/181abd18ba/../models/Spectre_lib/181aBD18BA_Rev3p7p0.scs" section=tt_n_dvt_ppoly_5p0v
include "/data/codesign/tyb/wuhan/dbht180xh/pdk/pdk_1p5m/181abd18ba/../models/Spectre_lib/181aBD18BA_Rev3p7p0.scs" section=tt_p_des_ftr_20v
include "/data/codesign/tyb/wuhan/dbht180xh/pdk/pdk_1p5m/181abd18ba/../models/Spectre_lib/181aBD18BA_Rev3p7p0.scs" section=tt_p_dea_nbl_n_85v
include "/data/codesign/tyb/wuhan/dbht180xh/pdk/pdk_1p5m/181abd18ba/../models/Spectre_lib/181aBD18BA_Rev3p7p0.scs" section=tt_p_dea_nbl_n_65v
include "/data/codesign/tyb/wuhan/dbht180xh/pdk/pdk_1p5m/181abd18ba/../models/Spectre_lib/181aBD18BA_Rev3p7p0.scs" section=tt_p_dea_nbl_n_120v
include "/data/codesign/tyb/wuhan/dbht180xh/pdk/pdk_1p5m/181abd18ba/../models/Spectre_lib/181aBD18BA_Rev3p7p0.scs" section=tt_n_dea_120v
include "/data/codesign/tyb/wuhan/dbht180xh/pdk/pdk_1p5m/181abd18ba/../models/Spectre_lib/181aBD18BA_Rev3p7p0.scs" section=norflag_demos
include "/data/codesign/tyb/wuhan/dbht180xh/pdk/pdk_1p5m/181abd18ba/../models/Spectre_lib/181aBD18BA_Rev3p7p0.scs" section=tt_p_dea_nbl_l_105v
include "/data/codesign/tyb/wuhan/dbht180xh/pdk/pdk_1p5m/181abd18ba/../models/Spectre_lib/181aBD18BA_Rev3p7p0.scs" section=tt_p_dea_nbl_65v
include "/data/codesign/tyb/wuhan/dbht180xh/pdk/pdk_1p5m/181abd18ba/../models/Spectre_lib/181aBD18BA_Rev3p7p0.scs" section=tt_p_dea_nbl_55v
include "/data/codesign/tyb/wuhan/dbht180xh/pdk/pdk_1p5m/181abd18ba/../models/Spectre_lib/181aBD18BA_Rev3p7p0.scs" section=tt_p_dea_nbl_30v
include "/data/codesign/tyb/wuhan/dbht180xh/pdk/pdk_1p5m/181abd18ba/../models/Spectre_lib/181aBD18BA_Rev3p7p0.scs" section=tt_p_dea_nbl_105v
include "/data/codesign/tyb/wuhan/dbht180xh/pdk/pdk_1p5m/181abd18ba/../models/Spectre_lib/181aBD18BA_Rev3p7p0.scs" section=tt_n_dea_iso_pbl_30v
include "/data/codesign/tyb/wuhan/dbht180xh/pdk/pdk_1p5m/181abd18ba/../models/Spectre_lib/181aBD18BA_Rev3p7p0.scs" section=tt_n_dea_iso_pbl_20v
include "/data/codesign/tyb/wuhan/dbht180xh/pdk/pdk_1p5m/181abd18ba/../models/Spectre_lib/181aBD18BA_Rev3p7p0.scs" section=tt_n_dea_hs_55v
include "/data/codesign/tyb/wuhan/dbht180xh/pdk/pdk_1p5m/181abd18ba/../models/Spectre_lib/181aBD18BA_Rev3p7p0.scs" section=tt_n_dea_105v
include "/data/codesign/tyb/wuhan/dbht180xh/pdk/pdk_1p5m/181abd18ba/../models/Spectre_lib/181aBD18BA_Rev3p7p0.scs" section=tt_n_dea_85v
include "/data/codesign/tyb/wuhan/dbht180xh/pdk/pdk_1p5m/181abd18ba/../models/Spectre_lib/181aBD18BA_Rev3p7p0.scs" section=tt_n_dea_65v
include "/data/codesign/tyb/wuhan/dbht180xh/pdk/pdk_1p5m/181abd18ba/../models/Spectre_lib/181aBD18BA_Rev3p7p0.scs" section=tt_n_dea_55v
include "/data/codesign/tyb/wuhan/dbht180xh/pdk/pdk_1p5m/181abd18ba/../models/Spectre_lib/181aBD18BA_Rev3p7p0.scs" section=tt_n_dea_30v
include "/data/codesign/tyb/wuhan/dbht180xh/pdk/pdk_1p5m/181abd18ba/../models/Spectre_lib/181aBD18BA_Rev3p7p0.scs" section=tt_p_dea_nbl_24v
include "/data/codesign/tyb/wuhan/dbht180xh/pdk/pdk_1p5m/181abd18ba/../models/Spectre_lib/181aBD18BA_Rev3p7p0.scs" section=tt_p_dea_nbl_20v
include "/data/codesign/tyb/wuhan/dbht180xh/pdk/pdk_1p5m/181abd18ba/../models/Spectre_lib/181aBD18BA_Rev3p7p0.scs" section=tt_n_dea_l_20v
include "/data/codesign/tyb/wuhan/dbht180xh/pdk/pdk_1p5m/181abd18ba/../models/Spectre_lib/181aBD18BA_Rev3p7p0.scs" section=tt_n_dea_24v
include "/data/codesign/tyb/wuhan/dbht180xh/pdk/pdk_1p5m/181abd18ba/../models/Spectre_lib/181aBD18BA_Rev3p7p0.scs" section=tt_n_dea_20v
include "/data/codesign/tyb/wuhan/dbht180xh/pdk/pdk_1p5m/181abd18ba/../models/Spectre_lib/181aBD18BA_Rev3p7p0.scs" section=tt_p_ldm_sp_20v
include "/data/codesign/tyb/wuhan/dbht180xh/pdk/pdk_1p5m/181abd18ba/../models/Spectre_lib/181aBD18BA_Rev3p7p0.scs" section=tt_p_ldm_n_60v
include "/data/codesign/tyb/wuhan/dbht180xh/pdk/pdk_1p5m/181abd18ba/../models/Spectre_lib/181aBD18BA_Rev3p7p0.scs" section=tt_p_ldm_n_120v
include "/data/codesign/tyb/wuhan/dbht180xh/pdk/pdk_1p5m/181abd18ba/../models/Spectre_lib/181aBD18BA_Rev3p7p0.scs" section=tt_p_ldm_l_60v
include "/data/codesign/tyb/wuhan/dbht180xh/pdk/pdk_1p5m/181abd18ba/../models/Spectre_lib/181aBD18BA_Rev3p7p0.scs" section=tt_p_ldm_80v
include "/data/codesign/tyb/wuhan/dbht180xh/pdk/pdk_1p5m/181abd18ba/../models/Spectre_lib/181aBD18BA_Rev3p7p0.scs" section=tt_p_ldm_60v
include "/data/codesign/tyb/wuhan/dbht180xh/pdk/pdk_1p5m/181abd18ba/../models/Spectre_lib/181aBD18BA_Rev3p7p0.scs" section=tt_p_ldm_40v
include "/data/codesign/tyb/wuhan/dbht180xh/pdk/pdk_1p5m/181abd18ba/../models/Spectre_lib/181aBD18BA_Rev3p7p0.scs" section=tt_p_ldm_36v
include "/data/codesign/tyb/wuhan/dbht180xh/pdk/pdk_1p5m/181abd18ba/../models/Spectre_lib/181aBD18BA_Rev3p7p0.scs" section=tt_p_ldm_30v
include "/data/codesign/tyb/wuhan/dbht180xh/pdk/pdk_1p5m/181abd18ba/../models/Spectre_lib/181aBD18BA_Rev3p7p0.scs" section=tt_p_ldm_24v
include "/data/codesign/tyb/wuhan/dbht180xh/pdk/pdk_1p5m/181abd18ba/../models/Spectre_lib/181aBD18BA_Rev3p7p0.scs" section=tt_p_ldm_20v
include "/data/codesign/tyb/wuhan/dbht180xh/pdk/pdk_1p5m/181abd18ba/../models/Spectre_lib/181aBD18BA_Rev3p7p0.scs" section=tt_p_ldm_12v
include "/data/codesign/tyb/wuhan/dbht180xh/pdk/pdk_1p5m/181abd18ba/../models/Spectre_lib/181aBD18BA_Rev3p7p0.scs" section=tt_p_ldm_100v
include "/data/codesign/tyb/wuhan/dbht180xh/pdk/pdk_1p5m/181abd18ba/../models/Spectre_lib/181aBD18BA_Rev3p7p0.scs" section=tt_n_ldmls_l_80v
include "/data/codesign/tyb/wuhan/dbht180xh/pdk/pdk_1p5m/181abd18ba/../models/Spectre_lib/181aBD18BA_Rev3p7p0.scs" section=tt_n_ldmls_80v
include "/data/codesign/tyb/wuhan/dbht180xh/pdk/pdk_1p5m/181abd18ba/../models/Spectre_lib/181aBD18BA_Rev3p7p0.scs" section=tt_n_ldmls_60v
include "/data/codesign/tyb/wuhan/dbht180xh/pdk/pdk_1p5m/181abd18ba/../models/Spectre_lib/181aBD18BA_Rev3p7p0.scs" section=tt_n_ldmls_40v
include "/data/codesign/tyb/wuhan/dbht180xh/pdk/pdk_1p5m/181abd18ba/../models/Spectre_lib/181aBD18BA_Rev3p7p0.scs" section=tt_n_ldmls_36v
include "/data/codesign/tyb/wuhan/dbht180xh/pdk/pdk_1p5m/181abd18ba/../models/Spectre_lib/181aBD18BA_Rev3p7p0.scs" section=tt_n_ldmls_30v
include "/data/codesign/tyb/wuhan/dbht180xh/pdk/pdk_1p5m/181abd18ba/../models/Spectre_lib/181aBD18BA_Rev3p7p0.scs" section=tt_n_ldmls_24v
include "/data/codesign/tyb/wuhan/dbht180xh/pdk/pdk_1p5m/181abd18ba/../models/Spectre_lib/181aBD18BA_Rev3p7p0.scs" section=tt_n_ldmls_12v
include "/data/codesign/tyb/wuhan/dbht180xh/pdk/pdk_1p5m/181abd18ba/../models/Spectre_lib/181aBD18BA_Rev3p7p0.scs" section=tt_n_ldmls_120v
include "/data/codesign/tyb/wuhan/dbht180xh/pdk/pdk_1p5m/181abd18ba/../models/Spectre_lib/181aBD18BA_Rev3p7p0.scs" section=tt_n_ldmls_100v
include "/data/codesign/tyb/wuhan/dbht180xh/pdk/pdk_1p5m/181abd18ba/../models/Spectre_lib/181aBD18BA_Rev3p7p0.scs" section=tt_n_ldmhs_l_80v
include "/data/codesign/tyb/wuhan/dbht180xh/pdk/pdk_1p5m/181abd18ba/../models/Spectre_lib/181aBD18BA_Rev3p7p0.scs" section=tt_n_ldmhs_80v
include "/data/codesign/tyb/wuhan/dbht180xh/pdk/pdk_1p5m/181abd18ba/../models/Spectre_lib/181aBD18BA_Rev3p7p0.scs" section=tt_n_ldmhs_60v
include "/data/codesign/tyb/wuhan/dbht180xh/pdk/pdk_1p5m/181abd18ba/../models/Spectre_lib/181aBD18BA_Rev3p7p0.scs" section=tt_n_ldmhs_40v
include "/data/codesign/tyb/wuhan/dbht180xh/pdk/pdk_1p5m/181abd18ba/../models/Spectre_lib/181aBD18BA_Rev3p7p0.scs" section=tt_n_ldmhs_36v
include "/data/codesign/tyb/wuhan/dbht180xh/pdk/pdk_1p5m/181abd18ba/../models/Spectre_lib/181aBD18BA_Rev3p7p0.scs" section=tt_n_ldmhs_30v
include "/data/codesign/tyb/wuhan/dbht180xh/pdk/pdk_1p5m/181abd18ba/../models/Spectre_lib/181aBD18BA_Rev3p7p0.scs" section=tt_n_ldmhs_24v
include "/data/codesign/tyb/wuhan/dbht180xh/pdk/pdk_1p5m/181abd18ba/../models/Spectre_lib/181aBD18BA_Rev3p7p0.scs" section=tt_n_ldmhs_20v
include "/data/codesign/tyb/wuhan/dbht180xh/pdk/pdk_1p5m/181abd18ba/../models/Spectre_lib/181aBD18BA_Rev3p7p0.scs" section=tt_n_ldmhs_12v
include "/data/codesign/tyb/wuhan/dbht180xh/pdk/pdk_1p5m/181abd18ba/../models/Spectre_lib/181aBD18BA_Rev3p7p0.scs" section=tt_n_ldmhs_120v
include "/data/codesign/tyb/wuhan/dbht180xh/pdk/pdk_1p5m/181abd18ba/../models/Spectre_lib/181aBD18BA_Rev3p7p0.scs" section=tt_n_ldmhs_100v
include "/data/codesign/tyb/wuhan/dbht180xh/pdk/pdk_1p5m/181abd18ba/../models/Spectre_lib/181aBD18BA_Rev3p7p0.scs" section=tt_n_ldm_iso_60v
include "/data/codesign/tyb/wuhan/dbht180xh/pdk/pdk_1p5m/181abd18ba/../models/Spectre_lib/181aBD18BA_Rev3p7p0.scs" section=tt_n_ldm_iso_40v
include "/data/codesign/tyb/wuhan/dbht180xh/pdk/pdk_1p5m/181abd18ba/../models/Spectre_lib/181aBD18BA_Rev3p7p0.scs" section=tt_n_ldm_iso_36v
include "/data/codesign/tyb/wuhan/dbht180xh/pdk/pdk_1p5m/181abd18ba/../models/Spectre_lib/181aBD18BA_Rev3p7p0.scs" section=tt_n_ldm_iso_30v
include "/data/codesign/tyb/wuhan/dbht180xh/pdk/pdk_1p5m/181abd18ba/../models/Spectre_lib/181aBD18BA_Rev3p7p0.scs" section=tt_n_ldm_iso_24v
include "/data/codesign/tyb/wuhan/dbht180xh/pdk/pdk_1p5m/181abd18ba/../models/Spectre_lib/181aBD18BA_Rev3p7p0.scs" section=tt_n_ldm_iso_20v
include "/data/codesign/tyb/wuhan/dbht180xh/pdk/pdk_1p5m/181abd18ba/../models/Spectre_lib/181aBD18BA_Rev3p7p0.scs" section=tt_n_ldm_iso_12v
include "/data/codesign/tyb/wuhan/dbht180xh/pdk/pdk_1p5m/181abd18ba/../models/Spectre_lib/181aBD18BA_Rev3p7p0.scs" section=norflag_esd050
include "/data/codesign/tyb/wuhan/dbht180xh/pdk/pdk_1p5m/181abd18ba/../models/Spectre_lib/181aBD18BA_Rev3p7p0.scs" section=norflag_esd018
include "/data/codesign/tyb/wuhan/dbht180xh/pdk/pdk_1p5m/181abd18ba/../models/Spectre_lib/181aBD18BA_Rev3p7p0.scs" section=tt_esd050
include "/data/codesign/tyb/wuhan/dbht180xh/pdk/pdk_1p5m/181abd18ba/../models/Spectre_lib/181aBD18BA_Rev3p7p0.scs" section=tt_esd018
include "/data/codesign/tyb/wuhan/dbht180xh/pdk/pdk_1p5m/181abd18ba/../models/Spectre_lib/181aBD18BA_Rev3p7p0.scs" section=tt_esd_dio
include "/data/codesign/tyb/wuhan/dbht180xh/pdk/pdk_1p5m/181abd18ba/../models/Spectre_lib/181aBD18BA_Rev3p7p0.scs" section=norflag_bjt
include "/data/codesign/tyb/wuhan/dbht180xh/pdk/pdk_1p5m/181abd18ba/../models/Spectre_lib/181aBD18BA_Rev3p7p0.scs" section=tt_bip_pnp
include "/data/codesign/tyb/wuhan/dbht180xh/pdk/pdk_1p5m/181abd18ba/../models/Spectre_lib/181aBD18BA_Rev3p7p0.scs" section=tt_bip_npn
include "/data/codesign/tyb/wuhan/dbht180xh/pdk/pdk_1p5m/181abd18ba/../models/Spectre_lib/181aBD18BA_Rev3p7p0.scs" section=tt_dio_stk
include "/data/codesign/tyb/wuhan/dbht180xh/pdk/pdk_1p5m/181abd18ba/../models/Spectre_lib/181aBD18BA_Rev3p7p0.scs" section=tt_dio_p
include "/data/codesign/tyb/wuhan/dbht180xh/pdk/pdk_1p5m/181abd18ba/../models/Spectre_lib/181aBD18BA_Rev3p7p0.scs" section=tt_dio
include "/data/codesign/tyb/wuhan/dbht180xh/pdk/pdk_1p5m/181abd18ba/../models/Spectre_lib/181aBD18BA_Rev3p7p0.scs" section=tt_dio_z
include "/data/codesign/tyb/wuhan/dbht180xh/pdk/pdk_1p5m/181abd18ba/../models/Spectre_lib/181aBD18BA_Rev3p7p0.scs" section=norflag_res
include "/data/codesign/tyb/wuhan/dbht180xh/pdk/pdk_1p5m/181abd18ba/../models/Spectre_lib/181aBD18BA_Rev3p7p0.scs" section=tt_res
include "/data/codesign/tyb/wuhan/dbht180xh/pdk/pdk_1p5m/181abd18ba/../models/Spectre_lib/181aBD18BA_Rev3p7p0.scs" section=norflag_cap
include "/data/codesign/tyb/wuhan/dbht180xh/pdk/pdk_1p5m/181abd18ba/../models/Spectre_lib/181aBD18BA_Rev3p7p0.scs" section=tt_cap
include "/data/codesign/tyb/wuhan/dbht180xh/pdk/pdk_1p5m/181abd18ba/../models/Spectre_lib/181aBD18BA_Rev3p7p0.scs" section=norflag_var
include "/data/codesign/tyb/wuhan/dbht180xh/pdk/pdk_1p5m/181abd18ba/../models/Spectre_lib/181aBD18BA_Rev3p7p0.scs" section=tt_var
include "/data/codesign/tyb/wuhan/dbht180xh/pdk/pdk_1p5m/181abd18ba/../models/Spectre_lib/181aBD18BA_Rev3p7p0.scs" section=norflag_mom
include "/data/codesign/tyb/wuhan/dbht180xh/pdk/pdk_1p5m/181abd18ba/../models/Spectre_lib/181aBD18BA_Rev3p7p0.scs" section=tt_mom
include "/data/codesign/tyb/wuhan/dbht180xh/pdk/pdk_1p5m/181abd18ba/../models/Spectre_lib/181aBD18BA_Rev3p7p0.scs" section=tt_eecel
include "/data/codesign/tyb/wuhan/dbht180xh/pdk/pdk_1p5m/181abd18ba/../models/Spectre_lib/181aBD18BA_Rev3p7p0.scs" section=tt_ecel
include "/data/codesign/tyb/wuhan/dbht180xh/pdk/pdk_1p5m/181abd18ba/../models/Spectre_lib/181aBD18BA_Rev3p7p0.scs" section=setup
include "/data/codesign/tyb/wuhan/dbht180xh/pdk/pdk_1p5m/181abd18ba/../models/Spectre_lib/181aBD18BA_Rev3p7p0.scs" section=agemos
// CMP_LG/INV/schematic
subckt INV A NISO O PEPI PSUB VDD VSS
    M1 (O A VSS PEPI NISO PSUB) nch_svt_iso_nbl_6p0v l=l_M1 w=w_M1_per_finger multi=nf_M1 m=1 option_vop=7.7 trise=0 isoring=0 option_dti=0
    M0 (O A VDD VDD PEPI NISO PSUB) pch_svt_iso_nbl_6p0v l=l_M0 w=w_M0_per_finger multi=nf_M0 m=1 option_vop=7.7 trise=0 isoring=0 option_dti=0
ends INV
// CMP_LG/AMP_Core/schematic
subckt AMP_Core D_COMP_OUT IBNI1U NISO PEPI PSUB VDD VINN_VC VINP_RAMP VSS
    M22 (net022 net014 VDD VDD PEPI NISO PSUB) pch_svt_iso_nbl_6p0v l=l_M22 w=w_M22_per_finger multi=nf_M22 m=2 option_vop=7.7 trise=0 isoring=0 option_dti=0
    M23 (net044 VBP1 VDD VDD PEPI NISO PSUB) pch_svt_iso_nbl_6p0v l=l_M23 w=w_M23_per_finger multi=nf_M23 m=1 option_vop=7.7 trise=0 isoring=0 option_dti=0
    M20 (net053 net20 VDD VDD PEPI NISO PSUB) pch_svt_iso_nbl_6p0v l=l_M20 w=w_M20_per_finger multi=nf_M20 m=1 option_vop=7.7 trise=0 isoring=0 option_dti=0
    M10 (VBN1 net014 VDD VDD PEPI NISO PSUB) pch_svt_iso_nbl_6p0v l=l_M10 w=w_M10_per_finger multi=nf_M10 m=2 option_vop=7.7 trise=0 isoring=0 option_dti=0
    M8 (VBP1 VBP1 net044 VDD PEPI NISO PSUB) pch_svt_iso_nbl_6p0v l=l_M8 w=w_M8_per_finger multi=nf_M8 m=1 option_vop=7.7 trise=0 isoring=0 option_dti=0
    M18 (net13 VBP1 net039 VDD PEPI NISO PSUB) pch_svt_iso_nbl_6p0v l=l_M18 w=w_M18_per_finger multi=nf_M18 m=1 option_vop=7.7 trise=0 isoring=0 option_dti=0
    M19 (net20 VBP1 net25 VDD PEPI NISO PSUB) pch_svt_iso_nbl_6p0v l=l_M19 w=w_M19_per_finger multi=nf_M19 m=1 option_vop=7.7 trise=0 isoring=0 option_dti=0
    M16 (net25 net13 VDD VDD PEPI NISO PSUB) pch_svt_iso_nbl_6p0v l=l_M16 w=w_M16_per_finger multi=nf_M16 m=2 option_vop=7.7 trise=0 isoring=0 option_dti=0
    M17 (net039 net13 VDD VDD PEPI NISO PSUB) pch_svt_iso_nbl_6p0v l=l_M17 w=w_M17_per_finger multi=nf_M17 m=2 option_vop=7.7 trise=0 isoring=0 option_dti=0
    M6 (net23 VINN_VC net14 VDD PEPI NISO PSUB) pch_svt_iso_nbl_6p0v l=l_M6 w=w_M6_per_finger multi=nf_M6 m=4 option_vop=7.7 trise=0 isoring=0 option_dti=0
    M4 (net029 VINP_RAMP net14 VDD PEPI NISO PSUB) pch_svt_iso_nbl_6p0v l=l_M4 w=w_M4_per_finger multi=nf_M4 m=4 option_vop=7.7 trise=0 isoring=0 option_dti=0
    M3 (net014 net014 VDD VDD PEPI NISO PSUB) pch_svt_iso_nbl_6p0v l=l_M3 w=w_M3_per_finger multi=nf_M3 m=1 option_vop=7.7 trise=0 isoring=0 option_dti=0
    M7 (net14 net014 VDD VDD PEPI NISO PSUB) pch_svt_iso_nbl_6p0v l=l_M7 w=w_M7_per_finger multi=nf_M7 m=16 option_vop=7.7 trise=0 isoring=0 option_dti=0
    M30 (net022 net022 VSS PEPI NISO PSUB) nch_svt_iso_nbl_6p0v l=l_M30 w=w_M30_per_finger multi=nf_M30 m=1 option_vop=7.7 trise=0 isoring=0 option_dti=0
    M21 (net037 VBN1 VSS PEPI NISO PSUB) nch_svt_iso_nbl_6p0v l=l_M21 w=w_M21_per_finger multi=nf_M21 m=1 option_vop=7.7 trise=0 isoring=0 option_dti=0
    M27 (net053 VBN1 net034 PEPI NISO PSUB) nch_svt_iso_nbl_6p0v l=l_M27 w=w_M27_per_finger multi=nf_M27 m=1 option_vop=7.7 trise=0 isoring=0 option_dti=0
    M32 (net034 net022 VSS PEPI NISO PSUB) nch_svt_iso_nbl_6p0v l=l_M32 w=w_M32_per_finger multi=nf_M32 m=1 option_vop=7.7 trise=0 isoring=0 option_dti=0
    M9 (VBN1 VBN1 net037 PEPI NISO PSUB) nch_svt_iso_nbl_6p0v l=l_M9 w=w_M9_per_finger multi=nf_M9 m=1 option_vop=7.7 trise=0 isoring=0 option_dti=0
    M13 (VBP1 IBNI1U VSS PEPI NISO PSUB) nch_svt_iso_nbl_6p0v l=l_M13 w=w_M13_per_finger multi=nf_M13 m=3 option_vop=7.7 trise=0 isoring=0 option_dti=0
    M25 (net13 VBN1 net23 PEPI NISO PSUB) nch_svt_iso_nbl_6p0v l=l_M25 w=w_M25_per_finger multi=nf_M25 m=1 option_vop=7.7 trise=0 isoring=0 option_dti=0
    M26 (net20 VBN1 net029 PEPI NISO PSUB) nch_svt_iso_nbl_6p0v l=l_M26 w=w_M26_per_finger multi=nf_M26 m=1 option_vop=7.7 trise=0 isoring=0 option_dti=0
    M5 (IBNI1U IBNI1U VSS PEPI NISO PSUB) nch_svt_iso_nbl_6p0v l=l_M5 w=w_M5_per_finger multi=nf_M5 m=1 option_vop=7.7 trise=0 isoring=0 option_dti=0
    M12 (net014 IBNI1U VSS PEPI NISO PSUB) nch_svt_iso_nbl_6p0v l=l_M12 w=w_M12_per_finger multi=nf_M12 m=3 option_vop=7.7 trise=0 isoring=0 option_dti=0
    M14 (net23 net022 VSS PEPI NISO PSUB) nch_svt_iso_nbl_6p0v l=l_M14 w=w_M14_per_finger multi=nf_M14 m=2 option_vop=7.7 trise=0 isoring=0 option_dti=0
    M15 (net029 net022 VSS PEPI NISO PSUB) nch_svt_iso_nbl_6p0v l=l_M15 w=w_M15_per_finger multi=nf_M15 m=2 option_vop=7.7 trise=0 isoring=0 option_dti=0
    I1 (net33 NISO D_COMP_OUT PEPI PSUB VDD VSS) INV
    I5 (net053 NISO net33 PEPI PSUB VDD VSS) INV
ends AMP_Core
// CMP_LG/tb_CMP_Trans/schematic
V2 (VINN_VC VSS) vsource dc=1 type=dc
V0 (net06 VSS) vsource dc=vdd type=dc
V1 (VSS 0) vsource dc=0 type=dc
I1 (VSS net1) isource dc=1u type=dc
C0 (D_COMP_OUT VSS) capacitor c=1f
V3 (VINP_RAMP VSS) vsource dc=1 type=pulse val0=0 val1=1.5 period=81n delay=10n rise=80n fall=1n width=0
IPRB0 (net06 VDD) iprobe
I0 (D_COMP_OUT net1 VDD VSS VSS VDD VINN_VC VINP_RAMP VSS) AMP_Core
simulatorOptions options temp=27 inlinesubcktcurrent=subckt
tran tran stop=140n errpreset=conservative
