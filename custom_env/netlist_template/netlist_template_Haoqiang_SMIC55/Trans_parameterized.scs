// Design: LDO_Haoqiang/tb_Trans
simulator lang=spectre
global 0
parameters cpp=2p ibias C0 C1 C2 C3 C4 C8 R0 w_M47_per_finger l_M47 nf_M47 w_M46_per_finger l_M46 nf_M46 w_M42_per_finger l_M42 nf_M42 w_M41_per_finger l_M41 nf_M41 w_M27_per_finger l_M27 nf_M27 w_M26_per_finger l_M26 nf_M26 w_M25_per_finger l_M25 nf_M25 w_M24_per_finger l_M24 nf_M24 w_M23_per_finger l_M23 nf_M23 w_M19_per_finger l_M19 nf_M19 w_M22_per_finger l_M22 nf_M22 w_M15_per_finger l_M15 nf_M15 w_M14_per_finger l_M14 nf_M14 w_M6_per_finger l_M6 nf_M6 w_M21_per_finger l_M21 nf_M21 w_M1_per_finger l_M1 nf_M1 w_M36_per_finger l_M36 nf_M36 w_M35_per_finger l_M35 nf_M35 w_M34_per_finger l_M34 nf_M34 w_M13_per_finger l_M13 nf_M13 w_M33_per_finger l_M33 nf_M33 w_M32_per_finger l_M32 nf_M32 w_M31_per_finger l_M31 nf_M31 w_M20_per_finger l_M20 nf_M20 w_M18_per_finger l_M18 nf_M18 w_M11_per_finger l_M11 nf_M11 w_M10_per_finger l_M10 nf_M10 w_M8_per_finger l_M8 nf_M8 w_M7_per_finger l_M7 nf_M7 w_M12_per_finger l_M12 nf_M12 w_M4_per_finger l_M4 nf_M4 w_M2_per_finger l_M2 nf_M2 w_M40_per_finger l_M40 nf_M40 w_M0_per_finger l_M0 nf_M0 w_M38_per_finger l_M38 nf_M38 w_M37_per_finger l_M37 nf_M37 w_M9_per_finger l_M9 nf_M9 w_M5_per_finger l_M5 nf_M5 w_M3_per_finger l_M3 nf_M3 w_M43_per_finger l_M43 nf_M43 w_M44_per_finger l_M44 nf_M44 w_M30_per_finger l_M30 nf_M30 w_M29_per_finger l_M29 nf_M29 w_M28_per_finger l_M28 nf_M28 w_M17_per_finger l_M17 nf_M17 w_M16_per_finger l_M16 nf_M16 w_M45_per_finger l_M45 nf_M45
include "/data/PDK/pdk_installed/smic55/smic55ll_ulp_09121825_1P7M_6Ic_1TMc_ALPA1_oa_cds_v1.16_2/smic55ll_121825_1tm/../models/spectre/l0055ll_v1p16_spe.lib" section=tt
include "/data/PDK/pdk_installed/smic55/smic55ll_ulp_09121825_1P7M_6Ic_1TMc_ALPA1_oa_cds_v1.16_2/smic55ll_121825_1tm/../models/spectre/l0055ll_v1p16_spe.lib" section=ldmos_tt
include "/data/PDK/pdk_installed/smic55/smic55ll_ulp_09121825_1P7M_6Ic_1TMc_ALPA1_oa_cds_v1.16_2/smic55ll_121825_1tm/../models/spectre/l0055ll_v1p16_spe.lib" section=bjt_tt
include "/data/PDK/pdk_installed/smic55/smic55ll_ulp_09121825_1P7M_6Ic_1TMc_ALPA1_oa_cds_v1.16_2/smic55ll_121825_1tm/../models/spectre/l0055ll_v1p16_spe.lib" section=dio_tt
include "/data/PDK/pdk_installed/smic55/smic55ll_ulp_09121825_1P7M_6Ic_1TMc_ALPA1_oa_cds_v1.16_2/smic55ll_121825_1tm/../models/spectre/l0055ll_v1p16_spe.lib" section=res_tt
include "/data/PDK/pdk_installed/smic55/smic55ll_ulp_09121825_1P7M_6Ic_1TMc_ALPA1_oa_cds_v1.16_2/smic55ll_121825_1tm/../models/spectre/l0055ll_v1p16_spe.lib" section=var_tt
include "/data/PDK/pdk_installed/smic55/smic55ll_ulp_09121825_1P7M_6Ic_1TMc_ALPA1_oa_cds_v1.16_2/smic55ll_121825_1tm/../models/spectre/l0055ll_v1p16_spe.lib" section=mom_tt
// LDO_Haoqiang/bonding_wire/schematic
subckt bonding_wire VIN VOUT
    L0 (VIN net5) inductor l=1n
    R0 (net5 VOUT) resistor r=50m
ends bonding_wire
// LDO_Haoqiang/LDO_Core/schematic
subckt LDO_Core IBIAS VBODY VF1 VF2 VFB_FFRC VH VIN VOUT VOUT_MIR VREF VSET VSET_FB VSS
    M47 (V2_FFRC net077 VIN VIN) p12ll w=(w_M47_per_finger) * (nf_M47) l=l_M47 nf=nf_M47 m=1
    M46 (net077 net077 VIN VIN) p12ll w=(w_M46_per_finger) * (nf_M46) l=l_M46 nf=nf_M46 m=1
    M42 (net068 net068 VOUT VOUT) p12ll w=(w_M42_per_finger) * (nf_M42) l=l_M42 nf=nf_M42 m=1
    M41 (net069 net068 net0102 net0102) p12ll w=(w_M41_per_finger) * (nf_M41) l=l_M41 nf=nf_M41 m=1
    M27 (net066 net066 VIN VIN) p12ll w=(w_M27_per_finger) * (nf_M27) l=l_M27 nf=nf_M27 m=1
    M26 (VG_FFRC net066 VIN VIN) p12ll w=(w_M26_per_finger) * (nf_M26) l=l_M26 nf=nf_M26 m=1
    M25 (V1_FFRC VG_FFRC VIN VIN) p12ll w=(w_M25_per_finger) * (nf_M25) l=l_M25 nf=nf_M25 m=1
    M24 (V2_FFRC V2_FFRC VIN VIN) p12ll w=(w_M24_per_finger) * (nf_M24) l=l_M24 nf=nf_M24 m=1
    M23 (V3_SSF V2_FFRC VBODY VBODY) p12ll w=(w_M23_per_finger) * (nf_M23) l=l_M23 nf=nf_M23 m=1
    M19 (VOUT_MIR VG_VSET VIN VIN) p12ll w=(w_M19_per_finger) * (nf_M19) l=l_M19 nf=nf_M19 m=1
    M22 (VBODY net090 VIN VIN) p12ll w=(w_M22_per_finger) * (nf_M22) l=l_M22 nf=nf_M22 m=1
    M15 (VG_VSET net054 VIN VIN) p12ll w=(w_M15_per_finger) * (nf_M15) l=l_M15 nf=nf_M15 m=1
    M14 (net054 net054 VIN VIN) p12ll w=(w_M14_per_finger) * (nf_M14) l=l_M14 nf=nf_M14 m=1
    M6 (VSET VSET VOUT_MIR VOUT_MIR) p12ll w=(w_M6_per_finger) * (nf_M6) l=l_M6 nf=nf_M6 m=1
    M21 (net090 net090 VIN VIN) p12ll w=(w_M21_per_finger) * (nf_M21) l=l_M21 nf=nf_M21 m=1
    M1 (VF1 VSET VOUT VOUT) p12ll w=(w_M1_per_finger) * (nf_M1) l=l_M1 nf=nf_M1 m=1
    M36 (net092 IBIAS VSS VSS) n25ll w=(w_M36_per_finger) * (nf_M36) l=l_M36 nf=nf_M36 m=1
    M35 (net067 IB_FFRC VSS VSS) n25ll w=(w_M35_per_finger) * (nf_M35) l=l_M35 nf=nf_M35 m=1
    M34 (net090 IB_FFRC VSS VSS) n25ll w=(w_M34_per_finger) * (nf_M34) l=l_M34 nf=nf_M34 m=1
    M13 (V3_SSF IB_FFRC VSS VSS) n25ll w=(w_M13_per_finger) * (nf_M13) l=l_M13 nf=nf_M13 m=1
    M33 (IB_FFRC IB_FFRC VSS VSS) n25ll w=(w_M33_per_finger) * (nf_M33) l=l_M33 nf=nf_M33 m=1
    M32 (VG_FFRC VFB_FFRC net067 VSS) n25ll w=(w_M32_per_finger) * (nf_M32) l=l_M32 nf=nf_M32 m=1
    M31 (net066 VREF net067 VSS) n25ll w=(w_M31_per_finger) * (nf_M31) l=l_M31 nf=nf_M31 m=1
    M20 (net053 IBIAS VSS VSS) n25ll w=(w_M20_per_finger) * (nf_M20) l=l_M20 nf=nf_M20 m=1
    M18 (VSET IBIAS VSS VSS) n25ll w=(w_M18_per_finger) * (nf_M18) l=l_M18 nf=nf_M18 m=1
    M11 (IBIAS IBIAS VSS VSS) n25ll w=(w_M11_per_finger) * (nf_M11) l=l_M11 nf=nf_M11 m=1
    M10 (net25 IBIAS VSS VSS) n25ll w=(w_M10_per_finger) * (nf_M10) l=l_M10 nf=nf_M10 m=1
    M8 (VF3 VREF VF2 VSS) n25ll w=(w_M8_per_finger) * (nf_M8) l=l_M8 nf=nf_M8 m=1
    M7 (VF2 IBIAS VSS VSS) n25ll w=(w_M7_per_finger) * (nf_M7) l=l_M7 nf=nf_M7 m=1
    M12 (VG VF2 VSS VSS) n25ll w=(w_M12_per_finger) * (nf_M12) l=l_M12 nf=nf_M12 m=1
    M4 (VG IBIAS VSS VSS) n25ll w=(w_M4_per_finger) * (nf_M4) l=l_M4 nf=nf_M4 m=1
    M2 (VF1 IBIAS VSS VSS) n25ll w=(w_M2_per_finger) * (nf_M2) l=l_M2 nf=nf_M2 m=1
    R0 (VG net43) resistor r=R0
    C8 (V2_FFRC VSS) capacitor c=C8
    C4 (VG_FFRC VSS) capacitor c=C4
    C2 (VOUT_MIR VSS) capacitor c=C2
    C3 (VSET VSS) capacitor c=C3
    C0 (net43 VSS) capacitor c=C0
    C1 (VIN V1_FFRC) capacitor c=C1
    M40 (VIN VG net0102 net0102) nlvt12ll w=(w_M40_per_finger) * (nf_M40) l=l_M40 nf=nf_M40 m=1
    M0 (VIN VG VOUT VBODY) nlvt12ll w=(w_M0_per_finger) * (nf_M0) l=l_M0 nf=nf_M0 m=1
    M38 (IB_FFRC net092 VIN VIN) p25ll w=(w_M38_per_finger) * (nf_M38) l=l_M38 nf=nf_M38 m=1
    M37 (net092 net092 VIN VIN) p25ll w=(w_M37_per_finger) * (nf_M37) l=l_M37 nf=nf_M37 m=1
    M9 (net25 net25 VH VH) p25ll w=(w_M9_per_finger) * (nf_M9) l=l_M9 nf=nf_M9 m=1
    M5 (VG VF3 VH VH) p25ll w=(w_M5_per_finger) * (nf_M5) l=l_M5 nf=nf_M5 m=1
    M3 (VF3 net25 VH VH) p25ll w=(w_M3_per_finger) * (nf_M3) l=l_M3 nf=nf_M3 m=1
    M43 (net068 net069 VSS VSS) n12ll w=(w_M43_per_finger) * (nf_M43) l=l_M43 nf=nf_M43 m=1
    M44 (net069 net069 VSS VSS) n12ll w=(w_M44_per_finger) * (nf_M44) l=l_M44 nf=nf_M44 m=1
    M30 (V1_FFRC V1_FFRC VSS VSS) n12ll w=(w_M30_per_finger) * (nf_M30) l=l_M30 nf=nf_M30 m=1
    M29 (V2_FFRC V1_FFRC VSS VSS) n12ll w=(w_M29_per_finger) * (nf_M29) l=l_M29 nf=nf_M29 m=1
    M28 (VBODY V3_SSF VSS VSS) n12ll w=(w_M28_per_finger) * (nf_M28) l=l_M28 nf=nf_M28 m=1
    M17 (VG_VSET VREF net053 VSS) n12ll w=(w_M17_per_finger) * (nf_M17) l=l_M17 nf=nf_M17 m=1
    M16 (net054 VSET_FB net053 VSS) n12ll w=(w_M16_per_finger) * (nf_M16) l=l_M16 nf=nf_M16 m=1
    M45 (net077 net069 VSS VSS) n12ll w=(w_M45_per_finger) * (nf_M45) l=l_M45 nf=nf_M45 m=1
ends LDO_Core
// LDO_Haoqiang/probe/schematic
subckt probe VIN VSS
    C0 (VIN VSS) capacitor c=10p
    R0 (VIN VSS) resistor r=1M
ends probe
// LDO_Haoqiang/tb_Trans/schematic
I5 (VOUT_IS VOUT_OS) bonding_wire
V4 (VSS 0) vsource dc=0 type=dc
V3 (VH VSS) vsource dc=2 type=dc
V1 (VREF VSS) vsource dc=1 type=dc
V0 (VIN VSS) vsource dc=1.2 type=dc
I2 (VIN net6) isource dc=ibias type=dc
R0 (net014 VOUT_IS) resistor r=0
C0 (VOUT_IS VSS) capacitor c=cpp
I10 (net6 VBODY VFB_MIAN VFB_MIAN VBODY VH VIN net014 VFB_VSET VREF VSET VFB_VSET VSS) LDO_Core
I4 (VOUT_IS VSS) isource type=pwl wave=[ 2u 200u 2.01u 50m 7u 50m 7.01u 200u ]
I6 (VOUT_OS VSS) probe
simulatorOptions options temp=27
tran tran stop=10u errpreset=conservative
save R0:1 I10.M5:3 I10.M12:1
