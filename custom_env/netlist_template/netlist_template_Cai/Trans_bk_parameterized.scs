// Design: LDO_Cai/tb_Trans
simulator lang=spectre
global 0
parameters C1 C2 C3 CDDA IBP R1 VB1 VB2 VBN1 VBN2 VBP VBP1 VBP2 VD w_M57_per_finger l_M57 nf_M57 w_M46_per_finger l_M46 nf_M46 w_M55_per_finger l_M55 nf_M55 w_M45_per_finger l_M45 nf_M45 w_M44_per_finger l_M44 nf_M44 w_M43_per_finger l_M43 nf_M43 w_M14_per_finger l_M14 nf_M14 w_M19_per_finger l_M19 nf_M19 w_M18_per_finger l_M18 nf_M18 w_M16_per_finger l_M16 nf_M16 w_M11_per_finger l_M11 nf_M11 w_M35_per_finger l_M35 nf_M35 w_M34_per_finger l_M34 nf_M34 w_M33_per_finger l_M33 nf_M33 w_M10_per_finger l_M10 nf_M10 w_M9_per_finger l_M9 nf_M9 w_M8_per_finger l_M8 nf_M8 w_M7_per_finger l_M7 nf_M7 w_M0_per_finger l_M0 nf_M0 w_M2_per_finger l_M2 nf_M2 w_M1_per_finger l_M1 nf_M1 w_M56_per_finger l_M56 nf_M56 w_M54_per_finger l_M54 nf_M54 w_M53_per_finger l_M53 nf_M53 w_M50_per_finger l_M50 nf_M50 w_M51_per_finger l_M51 nf_M51 w_M52_per_finger l_M52 nf_M52 w_M49_per_finger l_M49 nf_M49 w_M48_per_finger l_M48 nf_M48 w_M47_per_finger l_M47 nf_M47 w_M42_per_finger l_M42 nf_M42 w_M41_per_finger l_M41 nf_M41 w_M40_per_finger l_M40 nf_M40 w_M13_per_finger l_M13 nf_M13 w_MP_per_finger l_MP nf_MP w_M15_per_finger l_M15 nf_M15 w_M17_per_finger l_M17 nf_M17 w_M20_per_finger l_M20 nf_M20 w_M12_per_finger l_M12 nf_M12 w_M32_per_finger l_M32 nf_M32 w_M31_per_finger l_M31 nf_M31 w_M23_per_finger l_M23 nf_M23 w_M22_per_finger l_M22 nf_M22 w_M21_per_finger l_M21 nf_M21 w_M6_per_finger l_M6 nf_M6 w_M5_per_finger l_M5 nf_M5 w_M4_per_finger l_M4 nf_M4 w_M3_per_finger l_M3 nf_M3
include "/data/PDK/pdk_installed/tsmc65_gp/tsmcN65/../models/spectre/crn65gplus_2d5_lk_v1d0.scs" section=tt_bip
include "/data/PDK/pdk_installed/tsmc65_gp/tsmcN65/../models/spectre/crn65gplus_2d5_lk_v1d0.scs" section=tt_dio
include "/data/PDK/pdk_installed/tsmc65_gp/tsmcN65/../models/spectre/crn65gplus_2d5_lk_v1d0.scs" section=tt_dio_33
include "/data/PDK/pdk_installed/tsmc65_gp/tsmcN65/../models/spectre/crn65gplus_2d5_lk_v1d0.scs" section=tt_mim
include "/data/PDK/pdk_installed/tsmc65_gp/tsmcN65/../models/spectre/crn65gplus_2d5_lk_v1d0.scs" section=tt_dio_dnw
include "/data/PDK/pdk_installed/tsmc65_gp/tsmcN65/../models/spectre/crn65gplus_2d5_lk_v1d0.scs" section=tt_dio_18
include "/data/PDK/pdk_installed/tsmc65_gp/tsmcN65/../models/spectre/crn65gplus_2d5_lk_v1d0.scs" section=tt_bip_npn
include "/data/PDK/pdk_installed/tsmc65_gp/tsmcN65/../models/spectre/crn65gplus_2d5_lk_v1d0.scs" section=tt_33
include "/data/PDK/pdk_installed/tsmc65_gp/tsmcN65/../models/spectre/crn65gplus_2d5_lk_v1d0.scs" section=tt_rfrtmom
include "/data/PDK/pdk_installed/tsmc65_gp/tsmcN65/../models/spectre/crn65gplus_2d5_lk_v1d0.scs" section=tt_mos_cap_25
include "/data/PDK/pdk_installed/tsmc65_gp/tsmcN65/../models/spectre/crn65gplus_2d5_lk_v1d0.scs" section=tt_18
include "/data/PDK/pdk_installed/tsmc65_gp/tsmcN65/../models/spectre/crn65gplus_2d5_lk_v1d0.scs" section=tt_disres
include "/data/PDK/pdk_installed/tsmc65_gp/tsmcN65/../models/spectre/crn65gplus_2d5_lk_v1d0.scs" section=tt_res
include "/data/PDK/pdk_installed/tsmc65_gp/tsmcN65/../models/spectre/crn65gplus_2d5_lk_v1d0.scs" section=tt_dio_na
include "/data/PDK/pdk_installed/tsmc65_gp/tsmcN65/../models/spectre/crn65gplus_2d5_lk_v1d0.scs" section=tt_rfmos_33
include "/data/PDK/pdk_installed/tsmc65_gp/tsmcN65/../models/spectre/crn65gplus_2d5_lk_v1d0.scs" section=tt_dio_hvt
include "/data/PDK/pdk_installed/tsmc65_gp/tsmcN65/../models/spectre/crn65gplus_2d5_lk_v1d0.scs" section=tt_rfmvar
include "/data/PDK/pdk_installed/tsmc65_gp/tsmcN65/../models/spectre/crn65gplus_2d5_lk_v1d0.scs" section=tt_rfmos_18
include "/data/PDK/pdk_installed/tsmc65_gp/tsmcN65/../models/spectre/crn65gplus_2d5_lk_v1d0.scs" section=tt_na
include "/data/PDK/pdk_installed/tsmc65_gp/tsmcN65/../models/spectre/crn65gplus_2d5_lk_v1d0.scs" section=tt_dio_na33
include "/data/PDK/pdk_installed/tsmc65_gp/tsmcN65/../models/spectre/crn65gplus_2d5_lk_v1d0.scs" section=tt_dio_lvt
include "/data/PDK/pdk_installed/tsmc65_gp/tsmcN65/../models/spectre/crn65gplus_2d5_lk_v1d0.scs" section=tt_rfres_sa
include "/data/PDK/pdk_installed/tsmc65_gp/tsmcN65/../models/spectre/crn65gplus_2d5_lk_v1d0.scs" section=tt_na33
include "/data/PDK/pdk_installed/tsmc65_gp/tsmcN65/../models/spectre/crn65gplus_2d5_lk_v1d0.scs" section=tt_dio_esd
include "/data/PDK/pdk_installed/tsmc65_gp/tsmcN65/../models/spectre/crn65gplus_2d5_lk_v1d0.scs" section=tt_rfmim
include "/data/PDK/pdk_installed/tsmc65_gp/tsmcN65/../models/spectre/crn65gplus_2d5_lk_v1d0.scs" section=tt_dio_25od33
include "/data/PDK/pdk_installed/tsmc65_gp/tsmcN65/../models/spectre/crn65gplus_2d5_lk_v1d0.scs" section=tt_25od33
include "/data/PDK/pdk_installed/tsmc65_gp/tsmcN65/../models/spectre/crn65gplus_2d5_lk_v1d0.scs" section=tt
include "/data/PDK/pdk_installed/tsmc65_gp/tsmcN65/../models/spectre/crn65gplus_2d5_lk_v1d0.scs" section=tt_mos_cap
include "/data/PDK/pdk_installed/tsmc65_gp/tsmcN65/../models/spectre/crn65gplus_2d5_lk_v1d0.scs" section=tt_dio_25
include "/data/PDK/pdk_installed/tsmc65_gp/tsmcN65/../models/spectre/crn65gplus_2d5_lk_v1d0.scs" section=tt_dio_25ud18
include "/data/PDK/pdk_installed/tsmc65_gp/tsmcN65/../models/spectre/crn65gplus_2d5_lk_v1d0.scs" section=tt_25
include "/data/PDK/pdk_installed/tsmc65_gp/tsmcN65/../models/spectre/crn65gplus_2d5_lk_v1d0.scs" section=tt_rfmos
include "/data/PDK/pdk_installed/tsmc65_gp/tsmcN65/../models/spectre/crn65gplus_2d5_lk_v1d0.scs" section=tt_25ud18
include "/data/PDK/pdk_installed/tsmc65_gp/tsmcN65/../models/spectre/crn65gplus_2d5_lk_v1d0.scs" section=tt_dio_na25od33
include "/data/PDK/pdk_installed/tsmc65_gp/tsmcN65/../models/spectre/crn65gplus_2d5_lk_v1d0.scs" section=tt_rfjvar
include "/data/PDK/pdk_installed/tsmc65_gp/tsmcN65/../models/spectre/crn65gplus_2d5_lk_v1d0.scs" section=tt_rfmos_25
include "/data/PDK/pdk_installed/tsmc65_gp/tsmcN65/../models/spectre/crn65gplus_2d5_lk_v1d0.scs" section=tt_rtmom
include "/data/PDK/pdk_installed/tsmc65_gp/tsmcN65/../models/spectre/crn65gplus_2d5_lk_v1d0.scs" section=tt_na25od33
include "/data/PDK/pdk_installed/tsmc65_gp/tsmcN65/../models/spectre/crn65gplus_2d5_lk_v1d0.scs" section=tt_dio_na25
include "/data/PDK/pdk_installed/tsmc65_gp/tsmcN65/../models/spectre/crn65gplus_2d5_lk_v1d0.scs" section=tt_rfres_rpo
include "/data/PDK/pdk_installed/tsmc65_gp/tsmcN65/../models/spectre/crn65gplus_2d5_lk_v1d0.scs" section=tt_hvt
include "/data/PDK/pdk_installed/tsmc65_gp/tsmcN65/../models/spectre/crn65gplus_2d5_lk_v1d0.scs" section=tt_rfind
include "/data/PDK/pdk_installed/tsmc65_gp/tsmcN65/../models/spectre/crn65gplus_2d5_lk_v1d0.scs" section=tt_rfmvar_25
include "/data/PDK/pdk_installed/tsmc65_gp/tsmcN65/../models/spectre/crn65gplus_2d5_lk_v1d0.scs" section=tt_na25
include "/data/PDK/pdk_installed/tsmc65_gp/tsmcN65/../models/spectre/crn65gplus_2d5_lk_v1d0.scs" section=tt_lvt
// LDO_Cai/LDO_Core/schematic
subckt LDO_Core IBP VB1 VB2 VBN1 VBN2 VBP VBP1 VBP2 VD VFB_IN VFB_OUT VIN VOUT VREF VSS
    M57 (S2 net059 VSS VSS) nch_mac l=l_M57 w=w_M57_per_finger*nf_M57 multi=1 nf=nf_M57 sigma=1 mismatchflag=1
    M46 (net059 net028 VSS VSS) nch_mac l=l_M46 w=w_M46_per_finger*nf_M46 multi=1 nf=nf_M46 sigma=1 mismatchflag=1
    M55 (S1 net044 VSS VSS) nch_mac l=l_M55 w=w_M55_per_finger*nf_M55 multi=1 nf=nf_M55 sigma=1 mismatchflag=1
    M45 (net044 net028 VSS VSS) nch_mac l=l_M45 w=w_M45_per_finger*nf_M45 multi=1 nf=nf_M45 sigma=1 mismatchflag=1
    M44 (net029 net028 VSS VSS) nch_mac l=l_M44 w=w_M44_per_finger*nf_M44 multi=1 nf=nf_M44 sigma=1 mismatchflag=1
    M43 (net028 net028 VSS VSS) nch_mac l=l_M43 w=w_M43_per_finger*nf_M43 multi=1 nf=nf_M43 sigma=1 mismatchflag=1
    M14 (VFB_OUT VB2 VSS VSS) nch_mac l=l_M14 w=w_M14_per_finger*nf_M14 multi=1 nf=nf_M14 sigma=1 mismatchflag=1
    M19 (VG VE VSS VSS) nch_mac l=l_M19 w=w_M19_per_finger*nf_M19 multi=1 nf=nf_M19 sigma=1 mismatchflag=1
    M18 (VE VD net052 VSS) nch_mac l=l_M18 w=w_M18_per_finger*nf_M18 multi=1 nf=nf_M18 sigma=1 mismatchflag=1
    M16 (net052 VB2 VSS VSS) nch_mac l=l_M16 w=w_M16_per_finger*nf_M16 multi=1 nf=nf_M16 sigma=1 mismatchflag=1
    M11 (VSET net25 VSS VSS) nch_mac l=l_M11 w=w_M11_per_finger*nf_M11 multi=1 nf=nf_M11 sigma=1 mismatchflag=1
    M35 (net29 VBN1 VSS VSS) nch_mac l=l_M35 w=w_M35_per_finger*nf_M35 multi=1 nf=nf_M35 sigma=1 mismatchflag=1
    M34 (V_AUX_OUT VREF net29 VSS) nch_mac l=l_M34 w=w_M34_per_finger*nf_M34 multi=1 nf=nf_M34 sigma=1 mismatchflag=1
    M33 (net31 V_AUX_P net29 VSS) nch_mac l=l_M33 w=w_M33_per_finger*nf_M33 multi=1 nf=nf_M33 sigma=1 mismatchflag=1
    M10 (net42 net16 VSS VSS) nch_mac l=l_M10 w=w_M10_per_finger*nf_M10 multi=1 nf=nf_M10 sigma=1 mismatchflag=1
    M9 (net43 net16 VSS VSS) nch_mac l=l_M9 w=w_M9_per_finger*nf_M9 multi=1 nf=nf_M9 sigma=1 mismatchflag=1
    M8 (net25 VBN2 net42 VSS) nch_mac l=l_M8 w=w_M8_per_finger*nf_M8 multi=1 nf=nf_M8 sigma=1 mismatchflag=1
    M7 (net16 VBN2 net43 VSS) nch_mac l=l_M7 w=w_M7_per_finger*nf_M7 multi=1 nf=nf_M7 sigma=1 mismatchflag=1
    M0 (net13 VB1 VSS VSS) nch_mac l=l_M0 w=w_M0_per_finger*nf_M0 multi=1 nf=nf_M0 sigma=1 mismatchflag=1
    M2 (net37 VREF net13 VSS) nch_mac l=l_M2 w=w_M2_per_finger*nf_M2 multi=1 nf=nf_M2 sigma=1 mismatchflag=1
    M1 (net36 VOUT net13 VSS) nch_mac l=l_M1 w=w_M1_per_finger*nf_M1 multi=1 nf=nf_M1 sigma=1 mismatchflag=1
    M56 (S2 net059 VIN VIN) pch_mac l=l_M56 w=w_M56_per_finger*nf_M56 multi=1 nf=nf_M56 sigma=1 mismatchflag=1
    M54 (S1 net044 VIN VIN) pch_mac l=l_M54 w=w_M54_per_finger*nf_M54 multi=1 nf=nf_M54 sigma=1 mismatchflag=1
    M53 (net059 S2 net084 VIN) pch_mac l=l_M53 w=w_M53_per_finger*nf_M53 multi=1 nf=nf_M53 sigma=1 mismatchflag=1
    M50 (net044 S1 net085 VIN) pch_mac l=l_M50 w=w_M50_per_finger*nf_M50 multi=1 nf=nf_M50 sigma=1 mismatchflag=1
    M51 (net059 IBP VOUT VOUT) pch_mac l=l_M51 w=w_M51_per_finger*nf_M51 multi=1 nf=nf_M51 sigma=1 mismatchflag=1
    M52 (net084 IBP VOUT VOUT) pch_mac l=l_M52 w=w_M52_per_finger*nf_M52 multi=1 nf=nf_M52 sigma=1 mismatchflag=1
    M49 (net085 IBP VOUT VOUT) pch_mac l=l_M49 w=w_M49_per_finger*nf_M49 multi=1 nf=nf_M49 sigma=1 mismatchflag=1
    M48 (net044 IBP VOUT VOUT) pch_mac l=l_M48 w=w_M48_per_finger*nf_M48 multi=1 nf=nf_M48 sigma=1 mismatchflag=1
    M47 (IBP IBP VOUT VOUT) pch_mac l=l_M47 w=w_M47_per_finger*nf_M47 multi=1 nf=nf_M47 sigma=1 mismatchflag=1
    M42 (net029 net029 VOUT VOUT) pch_mac l=l_M42 w=w_M42_per_finger*nf_M42 multi=1 nf=nf_M42 sigma=1 mismatchflag=1
    M41 (net028 net029 net086 net086) pch_mac l=l_M41 w=w_M41_per_finger*nf_M41 multi=1 nf=nf_M41 sigma=1 mismatchflag=1
    M40 (net086 VG VIN VIN) pch_mac l=l_M40 w=w_M40_per_finger*nf_M40 multi=1 nf=nf_M40 sigma=1 mismatchflag=1
    M13 (VFB_OUT VSET VOUT VOUT) pch_mac l=l_M13 w=w_M13_per_finger*nf_M13 multi=1 nf=nf_M13 sigma=1 mismatchflag=1
    MP (VOUT VG VIN VIN) pch_mac l=l_MP w=w_MP_per_finger*nf_MP multi=1 nf=nf_MP sigma=1 mismatchflag=1
    M15 (net052 VFB_IN VG VG) pch_mac l=l_M15 w=w_M15_per_finger*nf_M15 multi=1 nf=nf_M15 sigma=1 mismatchflag=1
    M17 (VE VBP VIN VIN) pch_mac l=l_M17 w=w_M17_per_finger*nf_M17 multi=1 nf=nf_M17 sigma=1 mismatchflag=1
    M20 (VG VBP VIN VIN) pch_mac l=l_M20 w=w_M20_per_finger*nf_M20 multi=1 nf=nf_M20 sigma=1 mismatchflag=1
    M12 (VSET VSET V_AUX_P V_AUX_P) pch_mac l=l_M12 w=w_M12_per_finger*nf_M12 multi=1 nf=nf_M12 sigma=1 mismatchflag=1
    M32 (V_AUX_OUT net31 VIN VIN) pch_mac l=l_M32 w=w_M32_per_finger*nf_M32 multi=1 nf=nf_M32 sigma=1 mismatchflag=1
    M31 (net31 net31 VIN VIN) pch_mac l=l_M31 w=w_M31_per_finger*nf_M31 multi=1 nf=nf_M31 sigma=1 mismatchflag=1
    M23 (V_AUX_P V_AUX_OUT VIN VIN) pch_mac l=l_M23 w=w_M23_per_finger*nf_M23 multi=1 nf=nf_M23 sigma=1 mismatchflag=1
    M22 (net39 S2 net25 net25) pch_mac l=l_M22 w=w_M22_per_finger*nf_M22 multi=1 nf=nf_M22 sigma=1 mismatchflag=1
    M21 (net41 S1 net25 net25) pch_mac l=l_M21 w=w_M21_per_finger*nf_M21 multi=1 nf=nf_M21 sigma=1 mismatchflag=1
    M6 (net25 VBP2 net37 VIN) pch_mac l=l_M6 w=w_M6_per_finger*nf_M6 multi=1 nf=nf_M6 sigma=1 mismatchflag=1
    M5 (net16 VBP2 net36 VIN) pch_mac l=l_M5 w=w_M5_per_finger*nf_M5 multi=1 nf=nf_M5 sigma=1 mismatchflag=1
    M4 (net37 VBP1 VIN VIN) pch_mac l=l_M4 w=w_M4_per_finger*nf_M4 multi=1 nf=nf_M4 sigma=1 mismatchflag=1
    M3 (net36 VBP1 VIN VIN) pch_mac l=l_M3 w=w_M3_per_finger*nf_M3 multi=1 nf=nf_M3 sigma=1 mismatchflag=1
    R1 (net41 net40) resistor r=R1
    CDDA (V_AUX_P VSS) capacitor c=CDDA
    C3 (net25 VSS) capacitor c=C3
    C2 (net39 VSS) capacitor c=C2
    C1 (net40 VSS) capacitor c=C1
ends LDO_Core
// LDO_Cai/tb_Trans/schematic
V10 (VBP1 0) vsource dc=VBP1 type=dc
V9 (VBP 0) vsource dc=VBP type=dc
V8 (VD 0) vsource dc=VD type=dc
V7 (VBP2 0) vsource dc=VBP2 type=dc
V6 (VBN1 0) vsource dc=VBN1 type=dc
V5 (VBN2 0) vsource dc=VBN2 type=dc
V4 (VB2 0) vsource dc=VB2 type=dc
V3 (VB1 0) vsource dc=VB1 type=dc
V2 (VIN 0) vsource dc=1.2 type=dc
V1 (VREF 0) vsource dc=1 type=dc
V0 (VSS 0) vsource dc=0 type=dc
I3 (IBP 0) isource dc=IBP type=dc
C0 (VOUT VSS) capacitor c=300p
I0 (IBP VB1 VB2 VBN1 VBN2 VBP VBP1 VBP2 VD VFB VFB VIN VOUT VREF VSS) LDO_Core
I1 (VOUT VSS) isource type=pulse val0=100u val1=20m period=10u delay=5u rise=800.0p fall=800.0p width=5u
simulatorOptions options temp=27
tran tran stop=15u errpreset=conservative
save I1:sink
