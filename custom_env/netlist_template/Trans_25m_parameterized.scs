// Design: LDO/tb_Trans
simulator lang=spectre
global 0
parameters I_MAX=25m CM R0 R1 IBP w_M13 l_M13 nf_M13 w_M12 l_M12 nf_M12 w_M11 l_M11 nf_M11 w_M2 l_M2 nf_M2 w_M10 l_M10 nf_M10 w_M9 l_M9 nf_M9 w_M6 l_M6 nf_M6 w_M5 l_M5 nf_M5 w_M4 l_M4 nf_M4 w_M1 l_M1 nf_M1 w_M0 l_M0 nf_M0
include "/data/PDK/pdk_installed/tsmc180bcd_g2/pdk/pdk_1p6m_2/tsmc18/../models/spectre/c018bcd_gen2_v1d6_usage.scs" section=pre_simu
include "/data/PDK/pdk_installed/tsmc180bcd_g2/pdk/pdk_1p6m_2/tsmc18/../models/spectre/c018bcd_gen2_v1d6_usage.scs" section=tt_lib
// LDO/EA_LDO/schematic
subckt EA_LDO IBP INN INP VDD VOUT VSS
    M13 (net25 net25 VSS VSS) nch_5_mac l=l_M13 w=w_M13 multi=1 nf=nf_M13 sigma=1 mismatchflag=1
    M12 (net19 net21 VSS VSS) nch_5_mac l=l_M12 w=w_M12 multi=1 nf=nf_M12 sigma=1 mismatchflag=1
    M11 (net21 net21 VSS VSS) nch_5_mac l=l_M11 w=w_M11 multi=1 nf=nf_M11 sigma=1 mismatchflag=1
    M2 (VOUT net25 VSS VSS) nch_5_mac l=l_M2 w=w_M2 multi=1 nf=nf_M2 sigma=1 mismatchflag=1
    M10 (net25 INP net017 VDD) pch_5_mac l=l_M10 w=w_M10 multi=1 nf=nf_M10 sigma=1 mismatchflag=1
    M9 (net21 INN net017 VDD) pch_5_mac l=l_M9 w=w_M9 multi=1 nf=nf_M9 sigma=1 mismatchflag=1
    M6 (VOUT net19 VDD VDD) pch_5_mac l=l_M6 w=w_M6 multi=1 nf=nf_M6 sigma=1 mismatchflag=1
    M5 (net19 net19 VDD VDD) pch_5_mac l=l_M5 w=w_M5 multi=1 nf=nf_M5 sigma=1 mismatchflag=1
    M4 (IBP IBP VDD VDD) pch_5_mac l=l_M4 w=w_M4 multi=1 nf=nf_M4 sigma=1 mismatchflag=1
    M1 (net017 IBP VDD VDD) pch_5_mac l=l_M1 w=w_M1 multi=1 nf=nf_M1 sigma=1 mismatchflag=1
ends EA_LDO
// LDO/tb_Trans/schematic
V0 (VDD 0) vsource dc=3.6 type=dc
V2 (VREF 0) vsource dc=1.2 type=dc
V1 (VSS 0) vsource dc=0 type=dc
I0 (IBP 0) isource dc=IBP type=dc
M0 (VOUT VG VDD VDD) pch_5_mac l=l_M0 w=w_M0 multi=1 nf=nf_M0 sigma=1 mismatchflag=1
I18 (IBP VREF VFB VDD VG VSS) EA_LDO
R0 (VOUT VFB) resistor r=R0
R1 (VFB VSS) resistor r=R1
C0 (VG VOUT) capacitor c=CM
C1 (VOUT VSS) capacitor c=1n
I19 (VOUT VSS) isource type=pulse val0=1u val1=I_MAX period=100u delay=50u rise=1n fall=1n width=50u
simulatorOptions options temp=27
tran tran stop=200u errpreset=conservative
save I19:sink
