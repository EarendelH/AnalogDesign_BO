// Design: LDO_JSSC2010_Mohamed_N65/tb_Trans
simulator lang=spectre
global 0
parameters CC1 CC2 CFF1 IB1 IB2 IB3 IB4 IB5 IB6 IB7 RC2 RF1 RF2 RFF1 RFF2 RS1 RS2 RS3 w_M14_per_finger l_M14 nf_M14 w_M3_per_finger l_M3 nf_M3 w_M4_per_finger l_M4 nf_M4 w_M8_per_finger l_M8 nf_M8 w_M7_per_finger l_M7 nf_M7 w_M13_per_finger l_M13 nf_M13 w_M18_per_finger l_M18 nf_M18 w_M6_per_finger l_M6 nf_M6 w_M5_per_finger l_M5 nf_M5 w_M12_per_finger l_M12 nf_M12 w_M10_per_finger l_M10 nf_M10 w_M9_per_finger l_M9 nf_M9 w_M1_per_finger l_M1 nf_M1 w_M2_per_finger l_M2 nf_M2 w_M0_per_finger l_M0 nf_M0 w_M16_per_finger l_M16 nf_M16 w_M15_per_finger l_M15 nf_M15
include "/data/codesign/tyb/wuhan/tsmc65_gp/tsmcN65/../models/spectre/crn65gplus_2d5_lk_v1d0.scs" section=tt_bip
include "/data/codesign/tyb/wuhan/tsmc65_gp/tsmcN65/../models/spectre/crn65gplus_2d5_lk_v1d0.scs" section=tt_dio
include "/data/codesign/tyb/wuhan/tsmc65_gp/tsmcN65/../models/spectre/crn65gplus_2d5_lk_v1d0.scs" section=tt_dio_33
include "/data/codesign/tyb/wuhan/tsmc65_gp/tsmcN65/../models/spectre/crn65gplus_2d5_lk_v1d0.scs" section=tt_mim
include "/data/codesign/tyb/wuhan/tsmc65_gp/tsmcN65/../models/spectre/crn65gplus_2d5_lk_v1d0.scs" section=tt_dio_dnw
include "/data/codesign/tyb/wuhan/tsmc65_gp/tsmcN65/../models/spectre/crn65gplus_2d5_lk_v1d0.scs" section=tt_dio_18
include "/data/codesign/tyb/wuhan/tsmc65_gp/tsmcN65/../models/spectre/crn65gplus_2d5_lk_v1d0.scs" section=tt_bip_npn
include "/data/codesign/tyb/wuhan/tsmc65_gp/tsmcN65/../models/spectre/crn65gplus_2d5_lk_v1d0.scs" section=tt_33
include "/data/codesign/tyb/wuhan/tsmc65_gp/tsmcN65/../models/spectre/crn65gplus_2d5_lk_v1d0.scs" section=tt_rfrtmom
include "/data/codesign/tyb/wuhan/tsmc65_gp/tsmcN65/../models/spectre/crn65gplus_2d5_lk_v1d0.scs" section=tt_mos_cap_25
include "/data/codesign/tyb/wuhan/tsmc65_gp/tsmcN65/../models/spectre/crn65gplus_2d5_lk_v1d0.scs" section=tt_18
include "/data/codesign/tyb/wuhan/tsmc65_gp/tsmcN65/../models/spectre/crn65gplus_2d5_lk_v1d0.scs" section=tt_disres
include "/data/codesign/tyb/wuhan/tsmc65_gp/tsmcN65/../models/spectre/crn65gplus_2d5_lk_v1d0.scs" section=tt_res
include "/data/codesign/tyb/wuhan/tsmc65_gp/tsmcN65/../models/spectre/crn65gplus_2d5_lk_v1d0.scs" section=tt_dio_na
include "/data/codesign/tyb/wuhan/tsmc65_gp/tsmcN65/../models/spectre/crn65gplus_2d5_lk_v1d0.scs" section=tt_rfmos_33
include "/data/codesign/tyb/wuhan/tsmc65_gp/tsmcN65/../models/spectre/crn65gplus_2d5_lk_v1d0.scs" section=tt_dio_hvt
include "/data/codesign/tyb/wuhan/tsmc65_gp/tsmcN65/../models/spectre/crn65gplus_2d5_lk_v1d0.scs" section=tt_rfmvar
include "/data/codesign/tyb/wuhan/tsmc65_gp/tsmcN65/../models/spectre/crn65gplus_2d5_lk_v1d0.scs" section=tt_rfmos_18
include "/data/codesign/tyb/wuhan/tsmc65_gp/tsmcN65/../models/spectre/crn65gplus_2d5_lk_v1d0.scs" section=tt_na
include "/data/codesign/tyb/wuhan/tsmc65_gp/tsmcN65/../models/spectre/crn65gplus_2d5_lk_v1d0.scs" section=tt_dio_na33
include "/data/codesign/tyb/wuhan/tsmc65_gp/tsmcN65/../models/spectre/crn65gplus_2d5_lk_v1d0.scs" section=tt_dio_lvt
include "/data/codesign/tyb/wuhan/tsmc65_gp/tsmcN65/../models/spectre/crn65gplus_2d5_lk_v1d0.scs" section=tt_rfres_sa
include "/data/codesign/tyb/wuhan/tsmc65_gp/tsmcN65/../models/spectre/crn65gplus_2d5_lk_v1d0.scs" section=tt_na33
include "/data/codesign/tyb/wuhan/tsmc65_gp/tsmcN65/../models/spectre/crn65gplus_2d5_lk_v1d0.scs" section=tt_dio_esd
include "/data/codesign/tyb/wuhan/tsmc65_gp/tsmcN65/../models/spectre/crn65gplus_2d5_lk_v1d0.scs" section=tt_rfmim
include "/data/codesign/tyb/wuhan/tsmc65_gp/tsmcN65/../models/spectre/crn65gplus_2d5_lk_v1d0.scs" section=tt_dio_25od33
include "/data/codesign/tyb/wuhan/tsmc65_gp/tsmcN65/../models/spectre/crn65gplus_2d5_lk_v1d0.scs" section=tt_25od33
include "/data/codesign/tyb/wuhan/tsmc65_gp/tsmcN65/../models/spectre/crn65gplus_2d5_lk_v1d0.scs" section=tt
include "/data/codesign/tyb/wuhan/tsmc65_gp/tsmcN65/../models/spectre/crn65gplus_2d5_lk_v1d0.scs" section=tt_mos_cap
include "/data/codesign/tyb/wuhan/tsmc65_gp/tsmcN65/../models/spectre/crn65gplus_2d5_lk_v1d0.scs" section=tt_dio_25
include "/data/codesign/tyb/wuhan/tsmc65_gp/tsmcN65/../models/spectre/crn65gplus_2d5_lk_v1d0.scs" section=tt_dio_25ud18
include "/data/codesign/tyb/wuhan/tsmc65_gp/tsmcN65/../models/spectre/crn65gplus_2d5_lk_v1d0.scs" section=tt_25
include "/data/codesign/tyb/wuhan/tsmc65_gp/tsmcN65/../models/spectre/crn65gplus_2d5_lk_v1d0.scs" section=tt_rfmos
include "/data/codesign/tyb/wuhan/tsmc65_gp/tsmcN65/../models/spectre/crn65gplus_2d5_lk_v1d0.scs" section=tt_25ud18
include "/data/codesign/tyb/wuhan/tsmc65_gp/tsmcN65/../models/spectre/crn65gplus_2d5_lk_v1d0.scs" section=tt_dio_na25od33
include "/data/codesign/tyb/wuhan/tsmc65_gp/tsmcN65/../models/spectre/crn65gplus_2d5_lk_v1d0.scs" section=tt_rfjvar
include "/data/codesign/tyb/wuhan/tsmc65_gp/tsmcN65/../models/spectre/crn65gplus_2d5_lk_v1d0.scs" section=tt_rfmos_25
include "/data/codesign/tyb/wuhan/tsmc65_gp/tsmcN65/../models/spectre/crn65gplus_2d5_lk_v1d0.scs" section=tt_rtmom
include "/data/codesign/tyb/wuhan/tsmc65_gp/tsmcN65/../models/spectre/crn65gplus_2d5_lk_v1d0.scs" section=tt_na25od33
include "/data/codesign/tyb/wuhan/tsmc65_gp/tsmcN65/../models/spectre/crn65gplus_2d5_lk_v1d0.scs" section=tt_dio_na25
include "/data/codesign/tyb/wuhan/tsmc65_gp/tsmcN65/../models/spectre/crn65gplus_2d5_lk_v1d0.scs" section=tt_rfres_rpo
include "/data/codesign/tyb/wuhan/tsmc65_gp/tsmcN65/../models/spectre/crn65gplus_2d5_lk_v1d0.scs" section=tt_hvt
include "/data/codesign/tyb/wuhan/tsmc65_gp/tsmcN65/../models/spectre/crn65gplus_2d5_lk_v1d0.scs" section=tt_rfind
include "/data/codesign/tyb/wuhan/tsmc65_gp/tsmcN65/../models/spectre/crn65gplus_2d5_lk_v1d0.scs" section=tt_rfmvar_25
include "/data/codesign/tyb/wuhan/tsmc65_gp/tsmcN65/../models/spectre/crn65gplus_2d5_lk_v1d0.scs" section=tt_na25
include "/data/codesign/tyb/wuhan/tsmc65_gp/tsmcN65/../models/spectre/crn65gplus_2d5_lk_v1d0.scs" section=tt_lvt
// LDO_JSSC2010_Mohamed_N65/LDO_Core/schematic
subckt LDO_Core VFB VIN VOUT VREF VSS
    M14 (net19 net24 net18 VSS) nch_mac l=l_M14 w=w_M14_per_finger*nf_M14 multi=1 nf=nf_M14 sigma=1 mismatchflag=1
    M3 (net41 net30 VSS VSS) nch_mac l=l_M3 w=w_M3_per_finger*nf_M3 multi=1 nf=nf_M3 sigma=1 mismatchflag=1
    M4 (net26 net30 VSS VSS) nch_mac l=l_M4 w=w_M4_per_finger*nf_M4 multi=1 nf=nf_M4 sigma=1 mismatchflag=1
    M8 (net17 net26 net13 VSS) nch_mac l=l_M8 w=w_M8_per_finger*nf_M8 multi=1 nf=nf_M8 sigma=1 mismatchflag=1
    M7 (net14 net5 net13 VSS) nch_mac l=l_M7 w=w_M7_per_finger*nf_M7 multi=1 nf=nf_M7 sigma=1 mismatchflag=1
    M13 (net15 VFB net18 VSS) nch_mac l=l_M13 w=w_M13_per_finger*nf_M13 multi=1 nf=nf_M13 sigma=1 mismatchflag=1
    I6 (net18 VSS) isource dc=IB7 type=dc
    I5 (net10 VSS) isource dc=IB6 type=dc
    I4 (net23 VSS) isource dc=IB5 type=dc
    I3 (net13 VSS) isource dc=IB4 type=dc
    I2 (net30 VSS) isource dc=IB3 type=dc
    I1 (net28 VSS) isource dc=IB2 type=dc
    I0 (VIN net29) isource dc=IB1 type=dc
    C2 (VIN net24) capacitor c=CFF1
    C1 (net45 VSS) capacitor c=CC2
    C0 (net26 net30) capacitor c=CC1
    R7 (VIN net24) resistor r=RFF1
    R6 (net10 net24) resistor r=RFF2
    R5 (net10 net45) resistor r=RC2
    R4 (net10 net5) resistor r=RS1
    R3 (net5 VSS) resistor r=RS3
    R2 (net5 net23) resistor r=RS2
    R1 (net33 VSS) resistor r=RF2
    R0 (VOUT net33) resistor r=RF1
    M18 (net10 net15 VIN VIN) pch_mac l=l_M18 w=w_M18_per_finger*nf_M18 multi=1 nf=nf_M18 sigma=1 mismatchflag=1
    M6 (net30 net28 net41 VDD) pch_mac l=l_M6 w=w_M6_per_finger*nf_M6 multi=1 nf=nf_M6 sigma=1 mismatchflag=1
    M5 (net28 net28 net26 VDD) pch_mac l=l_M5 w=w_M5_per_finger*nf_M5 multi=1 nf=nf_M5 sigma=1 mismatchflag=1
    M12 (net23 net17 VIN VDD) pch_mac l=l_M12 w=w_M12_per_finger*nf_M12 multi=1 nf=nf_M12 sigma=1 mismatchflag=1
    M10 (net17 net14 VIN VDD) pch_mac l=l_M10 w=w_M10_per_finger*nf_M10 multi=1 nf=nf_M10 sigma=1 mismatchflag=1
    M9 (net14 net14 VIN VDD) pch_mac l=l_M9 w=w_M9_per_finger*nf_M9 multi=1 nf=nf_M9 sigma=1 mismatchflag=1
    M1 (net26 VREF net29 VDD) pch_mac l=l_M1 w=w_M1_per_finger*nf_M1 multi=1 nf=nf_M1 sigma=1 mismatchflag=1
    M2 (net41 net33 net29 VDD) pch_mac l=l_M2 w=w_M2_per_finger*nf_M2 multi=1 nf=nf_M2 sigma=1 mismatchflag=1
    M0 (VOUT net23 VIN VIN) pch_mac l=l_M0 w=w_M0_per_finger*1 multi=nf_M0 nf=1 sigma=1 mismatchflag=1
    M16 (net19 net19 VIN VIN) pch_mac l=l_M16 w=w_M16_per_finger*nf_M16 multi=1 nf=nf_M16 sigma=1 mismatchflag=1
    M15 (net15 net19 VIN VIN) pch_mac l=l_M15 w=w_M15_per_finger*nf_M15 multi=1 nf=nf_M15 sigma=1 mismatchflag=1
ends LDO_Core
// LDO_JSSC2010_Mohamed_N65/tb_Trans/schematic
I0 (VOUT VIN VOUT VREF VSS) LDO_Core
C3 (net4 VSS) capacitor c=4u
R8 (VOUT net4) resistor r=30m
V2 (VIN 0) vsource dc=1.8 type=dc
V1 (VREF 0) vsource dc=1 type=dc
V0 (VSS 0) vsource dc=0 type=dc
I1 (VOUT VSS) isource dc=25m type=pulse val0=0 val1=25m period=20u delay=5u rise=10n fall=10n width=5u
simulatorOptions options temp=27
tran tran stop=15u errpreset=conservative
save I1:sink
