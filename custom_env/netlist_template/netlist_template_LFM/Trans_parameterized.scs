// Design: LDO_OPT_LouFM/tb_Trans
simulator lang=spectre
global 0
parameters ILOAD=500u VIN=1.2 VIN_AC=1 C31 C13 CLOAD BIAS BIAS_SF BIAS_CAP w_M11_per_finger l_M11 nf_M11 w_M32_per_finger l_M32 nf_M32 w_M35_per_finger l_M35 nf_M35 w_M33_per_finger l_M33 nf_M33 w_M22_per_finger l_M22 nf_M22 w_M18_per_finger l_M18 nf_M18 w_M16_per_finger l_M16 nf_M16 w_M30_per_finger l_M30 nf_M30 w_M15_per_finger l_M15 nf_M15 w_M9_per_finger l_M9 nf_M9 w_M89_per_finger l_M89 nf_M89 w_M88_per_finger l_M88 nf_M88 w_M87_per_finger l_M87 nf_M87 w_M80_per_finger l_M80 nf_M80 w_M81_per_finger l_M81 nf_M81 w_M63_per_finger l_M63 nf_M63 w_M62_per_finger l_M62 nf_M62 w_M54_per_finger l_M54 nf_M54 w_M60_per_finger l_M60 nf_M60 w_M83_per_finger l_M83 nf_M83 w_M53_per_finger l_M53 nf_M53 w_M43_per_finger l_M43 nf_M43 w_M59_per_finger l_M59 nf_M59 w_M82_per_finger l_M82 nf_M82 w_M52_per_finger l_M52 nf_M52 w_M28_per_finger l_M28 nf_M28 w_M42_per_finger l_M42 nf_M42 w_M19_per_finger l_M19 nf_M19 w_M20_per_finger l_M20 nf_M20 w_M61_per_finger l_M61 nf_M61 w_M101_per_finger l_M101 nf_M101 w_M100_per_finger l_M100 nf_M100 w_M98_per_finger l_M98 nf_M98 w_M97_per_finger l_M97 nf_M97 w_M96_per_finger l_M96 nf_M96 w_M95_per_finger l_M95 nf_M95 w_M94_per_finger l_M94 nf_M94 w_M91_per_finger l_M91 nf_M91 w_M90_per_finger l_M90 nf_M90 w_M72_per_finger l_M72 nf_M72 w_M71_per_finger l_M71 nf_M71 w_M70_per_finger l_M70 nf_M70 w_M69_per_finger l_M69 nf_M69 w_M67_per_finger l_M67 nf_M67 w_M66_per_finger l_M66 nf_M66 w_M51_per_finger l_M51 nf_M51 w_M50_per_finger l_M50 nf_M50 w_M49_per_finger l_M49 nf_M49 w_M48_per_finger l_M48 nf_M48 w_M47_per_finger l_M47 nf_M47 w_M41_per_finger l_M41 nf_M41 w_M40_per_finger l_M40 nf_M40 w_M39_per_finger l_M39 nf_M39 w_M36_per_finger l_M36 nf_M36 w_M31_per_finger l_M31 nf_M31 w_M26_per_finger l_M26 nf_M26 w_M25_per_finger l_M25 nf_M25 w_M57_per_finger l_M57 nf_M57 w_M14_per_finger l_M14 nf_M14 w_M13_per_finger l_M13 nf_M13 w_M12_per_finger l_M12 nf_M12 w_M8_per_finger l_M8 nf_M8 w_M3_per_finger l_M3 nf_M3 w_M0_per_finger l_M0 nf_M0 w_M1_per_finger l_M1 nf_M1 w_M21_per_finger l_M21 nf_M21 w_M17_per_finger l_M17 nf_M17 w_M45_per_finger l_M45 nf_M45 w_M44_per_finger l_M44 nf_M44 w_M68_per_finger l_M68 nf_M68 w_M56_per_finger l_M56 nf_M56 w_M55_per_finger l_M55 nf_M55 w_M34_per_finger l_M34 nf_M34 w_M29_per_finger l_M29 nf_M29 w_M27_per_finger l_M27 nf_M27 w_M85_per_finger l_M85 nf_M85 w_M86_per_finger l_M86 nf_M86 w_M46_per_finger l_M46 nf_M46 w_M38_per_finger l_M38 nf_M38 w_M37_per_finger l_M37 nf_M37 w_M24_per_finger l_M24 nf_M24 w_M23_per_finger l_M23 nf_M23 w_M2_per_finger l_M2 nf_M2 w_M4_per_finger l_M4 nf_M4 w_M6_per_finger l_M6 nf_M6 w_M10_per_finger l_M10 nf_M10 w_M5_per_finger l_M5 nf_M5 w_M7_per_finger l_M7 nf_M7
include "/data/PDK/pdk_installed/tsmc65_gp/tsmcN65/../models/spectre/crn65gplus_2d5_lk_v1d0.scs" section=tt_bip
include "/data/PDK/pdk_installed/tsmc65_gp/tsmcN65/../models/spectre/crn65gplus_2d5_lk_v1d0.scs" section=tt_dio
include "/data/PDK/pdk_installed/tsmc65_gp/tsmcN65/../models/spectre/crn65gplus_2d5_lk_v1d0.scs" section=tt_dio_33
include "/data/PDK/pdk_installed/tsmc65_gp/tsmcN65/../models/spectre/crn65gplus_2d5_lk_v1d0.scs" section=tt_mim
include "/data/PDK/pdk_installed/tsmc65_gp/tsmcN65/../models/spectre/crn65gplus_2d5_lk_v1d0.scs" section=tt_dio_dnw
include "/data/PDK/pdk_installed/tsmc65_gp/tsmcN65/../models/spectre/crn65gplus_2d5_lk_v1d0.scs" section=tt_dio_18
include "/data/PDK/pdk_installed/tsmc65_gp/tsmcN65/../models/spectre/crn65gplus_2d5_lk_v1d0.scs" section=tt_bip_npn
include "/data/PDK/pdk_installed/tsmc65_gp/tsmcN65/../models/spectre/crn65gplus_2d5_lk_v1d0.scs" section=tt_33
include "/data/PDK/pdk_installed/tsmc65_gp/tsmcN65/../models/spectre/crn65gplus_2d5_lk_v1d0.scs" section=tt_rfrtmom
include "/data/PDK/pdk_installed/tsmc65_gp/tsmcN65/../models/spectre/crn65gplus_2d5_lk_v1d0.scs" section=tt_mos_cap_25
include "/data/PDK/pdk_installed/tsmc65_gp/tsmcN65/../models/spectre/crn65gplus_2d5_lk_v1d0.scs" section=tt_18
include "/data/PDK/pdk_installed/tsmc65_gp/tsmcN65/../models/spectre/crn65gplus_2d5_lk_v1d0.scs" section=tt_disres
include "/data/PDK/pdk_installed/tsmc65_gp/tsmcN65/../models/spectre/crn65gplus_2d5_lk_v1d0.scs" section=tt_res
include "/data/PDK/pdk_installed/tsmc65_gp/tsmcN65/../models/spectre/crn65gplus_2d5_lk_v1d0.scs" section=tt_dio_na
include "/data/PDK/pdk_installed/tsmc65_gp/tsmcN65/../models/spectre/crn65gplus_2d5_lk_v1d0.scs" section=tt_rfmos_33
include "/data/PDK/pdk_installed/tsmc65_gp/tsmcN65/../models/spectre/crn65gplus_2d5_lk_v1d0.scs" section=tt_dio_hvt
include "/data/PDK/pdk_installed/tsmc65_gp/tsmcN65/../models/spectre/crn65gplus_2d5_lk_v1d0.scs" section=tt_rfmvar
include "/data/PDK/pdk_installed/tsmc65_gp/tsmcN65/../models/spectre/crn65gplus_2d5_lk_v1d0.scs" section=tt_rfmos_18
include "/data/PDK/pdk_installed/tsmc65_gp/tsmcN65/../models/spectre/crn65gplus_2d5_lk_v1d0.scs" section=tt_na
include "/data/PDK/pdk_installed/tsmc65_gp/tsmcN65/../models/spectre/crn65gplus_2d5_lk_v1d0.scs" section=tt_dio_na33
include "/data/PDK/pdk_installed/tsmc65_gp/tsmcN65/../models/spectre/crn65gplus_2d5_lk_v1d0.scs" section=tt_dio_lvt
include "/data/PDK/pdk_installed/tsmc65_gp/tsmcN65/../models/spectre/crn65gplus_2d5_lk_v1d0.scs" section=tt_rfres_sa
include "/data/PDK/pdk_installed/tsmc65_gp/tsmcN65/../models/spectre/crn65gplus_2d5_lk_v1d0.scs" section=tt_na33
include "/data/PDK/pdk_installed/tsmc65_gp/tsmcN65/../models/spectre/crn65gplus_2d5_lk_v1d0.scs" section=tt_dio_esd
include "/data/PDK/pdk_installed/tsmc65_gp/tsmcN65/../models/spectre/crn65gplus_2d5_lk_v1d0.scs" section=tt_rfmim
include "/data/PDK/pdk_installed/tsmc65_gp/tsmcN65/../models/spectre/crn65gplus_2d5_lk_v1d0.scs" section=tt_dio_25od33
include "/data/PDK/pdk_installed/tsmc65_gp/tsmcN65/../models/spectre/crn65gplus_2d5_lk_v1d0.scs" section=tt_25od33
include "/data/PDK/pdk_installed/tsmc65_gp/tsmcN65/../models/spectre/crn65gplus_2d5_lk_v1d0.scs" section=tt
include "/data/PDK/pdk_installed/tsmc65_gp/tsmcN65/../models/spectre/crn65gplus_2d5_lk_v1d0.scs" section=tt_mos_cap
include "/data/PDK/pdk_installed/tsmc65_gp/tsmcN65/../models/spectre/crn65gplus_2d5_lk_v1d0.scs" section=tt_dio_25
include "/data/PDK/pdk_installed/tsmc65_gp/tsmcN65/../models/spectre/crn65gplus_2d5_lk_v1d0.scs" section=tt_dio_25ud18
include "/data/PDK/pdk_installed/tsmc65_gp/tsmcN65/../models/spectre/crn65gplus_2d5_lk_v1d0.scs" section=tt_25
include "/data/PDK/pdk_installed/tsmc65_gp/tsmcN65/../models/spectre/crn65gplus_2d5_lk_v1d0.scs" section=tt_rfmos
include "/data/PDK/pdk_installed/tsmc65_gp/tsmcN65/../models/spectre/crn65gplus_2d5_lk_v1d0.scs" section=tt_25ud18
include "/data/PDK/pdk_installed/tsmc65_gp/tsmcN65/../models/spectre/crn65gplus_2d5_lk_v1d0.scs" section=tt_dio_na25od33
include "/data/PDK/pdk_installed/tsmc65_gp/tsmcN65/../models/spectre/crn65gplus_2d5_lk_v1d0.scs" section=tt_rfjvar
include "/data/PDK/pdk_installed/tsmc65_gp/tsmcN65/../models/spectre/crn65gplus_2d5_lk_v1d0.scs" section=tt_rfmos_25
include "/data/PDK/pdk_installed/tsmc65_gp/tsmcN65/../models/spectre/crn65gplus_2d5_lk_v1d0.scs" section=tt_rtmom
include "/data/PDK/pdk_installed/tsmc65_gp/tsmcN65/../models/spectre/crn65gplus_2d5_lk_v1d0.scs" section=tt_na25od33
include "/data/PDK/pdk_installed/tsmc65_gp/tsmcN65/../models/spectre/crn65gplus_2d5_lk_v1d0.scs" section=tt_dio_na25
include "/data/PDK/pdk_installed/tsmc65_gp/tsmcN65/../models/spectre/crn65gplus_2d5_lk_v1d0.scs" section=tt_rfres_rpo
include "/data/PDK/pdk_installed/tsmc65_gp/tsmcN65/../models/spectre/crn65gplus_2d5_lk_v1d0.scs" section=tt_hvt
include "/data/PDK/pdk_installed/tsmc65_gp/tsmcN65/../models/spectre/crn65gplus_2d5_lk_v1d0.scs" section=tt_rfind
include "/data/PDK/pdk_installed/tsmc65_gp/tsmcN65/../models/spectre/crn65gplus_2d5_lk_v1d0.scs" section=tt_rfmvar_25
include "/data/PDK/pdk_installed/tsmc65_gp/tsmcN65/../models/spectre/crn65gplus_2d5_lk_v1d0.scs" section=tt_na25
include "/data/PDK/pdk_installed/tsmc65_gp/tsmcN65/../models/spectre/crn65gplus_2d5_lk_v1d0.scs" section=tt_lvt
// LDO_OPT_LouFM/LDO_CORE/schematic
subckt LDO_CORE BIAS BIAS_CAP BIAS_SF GND STB_X STB_Y VDD VFB VOUT VREF
    M11 (GND V2 net08 VDD) pch_lvt_mac l=l_M11 w=w_M11_per_finger*nf_M11 multi=40 nf=nf_M11 sigma=1 mismatchflag=1
    M32 (net067 net067 GND GND) nch_25_mac l=l_M32 w=w_M32_per_finger*nf_M32 multi=2 nf=nf_M32 sigma=1 mismatchflag=1
    M35 (net065 net067 GND GND) nch_25_mac l=l_M35 w=w_M35_per_finger*nf_M35 multi=2 nf=nf_M35 sigma=1 mismatchflag=1
    M33 (EA_BIAS_N net0146 GND GND) nch_25_mac l=l_M33 w=w_M33_per_finger*nf_M33 multi=2 nf=nf_M33 sigma=1 mismatchflag=1
    M22 (net086 VB2 GND GND) nch_25_mac l=l_M22 w=w_M22_per_finger*nf_M22 multi=1 nf=nf_M22 sigma=1 mismatchflag=1
    M18 (VB1 VB2 GND GND) nch_25_mac l=l_M18 w=w_M18_per_finger*nf_M18 multi=2 nf=nf_M18 sigma=1 mismatchflag=1
    M16 (VB2 VB2 GND GND) nch_25_mac l=l_M16 w=w_M16_per_finger*nf_M16 multi=1 nf=nf_M16 sigma=1 mismatchflag=1
    M30 (net0146 net0146 GND GND) nch_25_mac l=l_M30 w=w_M30_per_finger*nf_M30 multi=2 nf=nf_M30 sigma=1 mismatchflag=1
    M15 (net0115 net073 GND GND) nch_25_mac l=l_M15 w=w_M15_per_finger*nf_M15 multi=1 nf=nf_M15 sigma=1 mismatchflag=1
    M9 (net0117 net073 GND GND) nch_25_mac l=l_M9 w=w_M9_per_finger*nf_M9 multi=1 nf=nf_M9 sigma=1 mismatchflag=1
    C13 (EA_BIAS_P net115) capacitor c=C13
    C31 (net031 GND) capacitor c=C31
    M89 (VB VB GND GND) nch_mac l=l_M89 w=w_M89_per_finger*nf_M89 multi=1 nf=nf_M89 sigma=1 mismatchflag=1
    M88 (net0164 VB net0144 GND) nch_mac l=l_M88 w=w_M88_per_finger*nf_M88 multi=2 nf=nf_M88 sigma=1 mismatchflag=1
    M87 (V2 VB net0161 GND) nch_mac l=l_M87 w=w_M87_per_finger*nf_M87 multi=2 nf=nf_M87 sigma=1 mismatchflag=1
    M80 (net0144 net0150 GND GND) nch_mac l=l_M80 w=w_M80_per_finger*nf_M80 multi=3 nf=nf_M80 sigma=1 mismatchflag=1
    M81 (net0161 net0159 GND GND) nch_mac l=l_M81 w=w_M81_per_finger*nf_M81 multi=3 nf=nf_M81 sigma=1 mismatchflag=1
    M63 (EA_BIAS_P net056 net0173 GND) nch_mac l=l_M63 w=w_M63_per_finger*nf_M63 multi=1 nf=nf_M63 sigma=1 mismatchflag=1
    M62 (net0180 net056 net0174 GND) nch_mac l=l_M62 w=w_M62_per_finger*nf_M62 multi=1 nf=nf_M62 sigma=1 mismatchflag=1
    M54 (net057 BIAS_EA_FC GND GND) nch_mac l=l_M54 w=w_M54_per_finger*nf_M54 multi=2 nf=nf_M54 sigma=1 mismatchflag=1
    M60 (net0143 VFB net052 GND) nch_mac l=l_M60 w=w_M60_per_finger*nf_M60 multi=2 nf=nf_M60 sigma=1 mismatchflag=1
    M83 (net0152 net0150 GND GND) nch_mac l=l_M83 w=w_M83_per_finger*nf_M83 multi=1 nf=nf_M83 sigma=1 mismatchflag=1
    M53 (net058 BIAS_EA_FC GND GND) nch_mac l=l_M53 w=w_M53_per_finger*nf_M53 multi=2 nf=nf_M53 sigma=1 mismatchflag=1
    M43 (net0174 net0180 GND GND) nch_mac l=l_M43 w=w_M43_per_finger*nf_M43 multi=1 nf=nf_M43 sigma=1 mismatchflag=1
    M59 (net0142 VREF net052 GND) nch_mac l=l_M59 w=w_M59_per_finger*nf_M59 multi=2 nf=nf_M59 sigma=1 mismatchflag=1
    M82 (net0228 net0159 GND GND) nch_mac l=l_M82 w=w_M82_per_finger*nf_M82 multi=1 nf=nf_M82 sigma=1 mismatchflag=1
    M52 (net0173 net0180 GND GND) nch_mac l=l_M52 w=w_M52_per_finger*nf_M52 multi=1 nf=nf_M52 sigma=1 mismatchflag=1
    M28 (net052 BIAS_EA_FC GND GND) nch_mac l=l_M28 w=w_M28_per_finger*nf_M28 multi=2 nf=nf_M28 sigma=1 mismatchflag=1
    M42 (BIAS_EA_FC BIAS_EA_FC GND GND) nch_mac l=l_M42 w=w_M42_per_finger*nf_M42 multi=2 nf=nf_M42 sigma=1 mismatchflag=1
    M19 (BIAS_FVF BIAS_FVF GND GND) nch_mac l=l_M19 w=w_M19_per_finger*nf_M19 multi=1 nf=nf_M19 sigma=1 mismatchflag=1
    M20 (STB_Y BIAS_FVF GND GND) nch_mac l=l_M20 w=w_M20_per_finger*nf_M20 multi=7 nf=nf_M20 sigma=1 mismatchflag=1
    M61 (net056 net056 GND GND) nch_25_mac l=l_M61 w=w_M61_per_finger*nf_M61 multi=1 nf=nf_M61 sigma=1 mismatchflag=1
    M101 (VB BIAS_EA_RFC VDD VDD) pch_mac l=l_M101 w=w_M101_per_finger*nf_M101 multi=1 nf=nf_M101 sigma=1 mismatchflag=1
    M100 (BIAS_EA_RFC BIAS_EA_RFC VDD VDD) pch_mac l=l_M100 w=w_M100_per_finger*nf_M100 multi=1 nf=nf_M100 sigma=1 mismatchflag=1
    M98 (net0154 BIAS_EA_RFC VDD VDD) pch_mac l=l_M98 w=w_M98_per_finger*nf_M98 multi=4 nf=nf_M98 sigma=1 mismatchflag=1
    M97 (V2 net0164 VDD VDD) pch_mac l=l_M97 w=w_M97_per_finger*nf_M97 multi=3 nf=nf_M97 sigma=1 mismatchflag=1
    M96 (net0164 net0164 VDD VDD) pch_mac l=l_M96 w=w_M96_per_finger*nf_M96 multi=3 nf=nf_M96 sigma=1 mismatchflag=1
    M95 (net0159 STB_X net0154 VDD) pch_mac l=l_M95 w=w_M95_per_finger*nf_M95 multi=2 nf=nf_M95 sigma=1 mismatchflag=1
    M94 (net0150 VOUT1 net0154 VDD) pch_mac l=l_M94 w=w_M94_per_finger*nf_M94 multi=2 nf=nf_M94 sigma=1 mismatchflag=1
    M91 (net0161 VOUT1 net0154 VDD) pch_mac l=l_M91 w=w_M91_per_finger*nf_M91 multi=2 nf=nf_M91 sigma=1 mismatchflag=1
    M90 (net0144 STB_X net0154 VDD) pch_mac l=l_M90 w=w_M90_per_finger*nf_M90 multi=2 nf=nf_M90 sigma=1 mismatchflag=1
    M72 (net056 net058 VDD VDD) pch_mac l=l_M72 w=w_M72_per_finger*nf_M72 multi=2 nf=nf_M72 sigma=1 mismatchflag=1
    M71 (net058 net058 VDD VDD) pch_mac l=l_M71 w=w_M71_per_finger*nf_M71 multi=2 nf=nf_M71 sigma=1 mismatchflag=1
    M70 (net0143 net058 VDD VDD) pch_mac l=l_M70 w=w_M70_per_finger*nf_M70 multi=1 nf=nf_M70 sigma=1 mismatchflag=1
    M69 (net0142 net058 VDD VDD) pch_mac l=l_M69 w=w_M69_per_finger*nf_M69 multi=1 nf=nf_M69 sigma=1 mismatchflag=1
    M67 (EA_BIAS_P net057 net0143 VDD) pch_mac l=l_M67 w=w_M67_per_finger*nf_M67 multi=1 nf=nf_M67 sigma=1 mismatchflag=1
    M66 (net0180 net057 net0142 VDD) pch_mac l=l_M66 w=w_M66_per_finger*nf_M66 multi=1 nf=nf_M66 sigma=1 mismatchflag=1
    M51 (net083 V2 VDD VDD) pch_mac l=l_M51 w=w_M51_per_finger*nf_M51 multi=1 nf=nf_M51 sigma=1 mismatchflag=1
    M50 (net080 net080 VDD VDD) pch_mac l=l_M50 w=w_M50_per_finger*nf_M50 multi=1 nf=nf_M50 sigma=1 mismatchflag=1
    M49 (net074 net080 VDD VDD) pch_mac l=l_M49 w=w_M49_per_finger*nf_M49 multi=2 nf=nf_M49 sigma=1 mismatchflag=1
    M48 (BIAS_CAP BIAS_CAP VDD VDD) pch_mac l=l_M48 w=w_M48_per_finger*nf_M48 multi=1 nf=nf_M48 sigma=1 mismatchflag=1
    M47 (net074 BIAS_CAP VDD VDD) pch_mac l=l_M47 w=w_M47_per_finger*nf_M47 multi=1 nf=nf_M47 sigma=1 mismatchflag=1
    M41 (VB2 BIAS_EA_CAP VDD VDD) pch_mac l=l_M41 w=w_M41_per_finger*nf_M41 multi=2 nf=nf_M41 sigma=1 mismatchflag=1
    M40 (BIAS_EA_CAP BIAS_EA_CAP VDD VDD) pch_mac l=l_M40 w=w_M40_per_finger*nf_M40 multi=2 nf=nf_M40 sigma=1 mismatchflag=1
    M39 (net076 BIAS_EA_CAP VDD VDD) pch_mac l=l_M39 w=w_M39_per_finger*nf_M39 multi=2 nf=nf_M39 sigma=1 mismatchflag=1
    M36 (net086 net086 VDD VDD) pch_mac l=l_M36 w=w_M36_per_finger*nf_M36 multi=2 nf=nf_M36 sigma=1 mismatchflag=1
    M31 (net115 net086 VDD VDD) pch_mac l=l_M31 w=w_M31_per_finger*nf_M31 multi=10 nf=nf_M31 sigma=1 mismatchflag=1
    M26 (net073 VB1 net0118 VDD) pch_mac l=l_M26 w=w_M26_per_finger*nf_M26 multi=1 nf=nf_M26 sigma=1 mismatchflag=1
    M25 (net079 VB1 net0116 VDD) pch_mac l=l_M25 w=w_M25_per_finger*nf_M25 multi=1 nf=nf_M25 sigma=1 mismatchflag=1
    M57 (net053 EA_BIAS_N net031 net053) pch_mac l=l_M57 w=w_M57_per_finger*nf_M57 multi=1 nf=nf_M57 sigma=1 mismatchflag=1
    M14 (GND net079 net115 VDD) pch_mac l=l_M14 w=w_M14_per_finger*nf_M14 multi=1 nf=nf_M14 sigma=1 mismatchflag=1
    M13 (BIAS_FVF net024 VDD VDD) pch_mac l=l_M13 w=w_M13_per_finger*nf_M13 multi=10 nf=nf_M13 sigma=1 mismatchflag=1
    M12 (BIAS_EA_FC net024 VDD VDD) pch_mac l=l_M12 w=w_M12_per_finger*nf_M12 multi=2 nf=nf_M12 sigma=1 mismatchflag=1
    M8 (net024 net024 VDD VDD) pch_mac l=l_M8 w=w_M8_per_finger*nf_M8 multi=2 nf=nf_M8 sigma=1 mismatchflag=1
    M3 (net06 VOUT1 V2 net06) pch_mac l=l_M3 w=w_M3_per_finger*nf_M3 multi=1 nf=nf_M3 sigma=1 mismatchflag=1
    M0 (net08 BIAS_SF VDD VDD) pch_mac l=l_M0 w=w_M0_per_finger*nf_M0 multi=40 nf=nf_M0 sigma=1 mismatchflag=1
    M1 (BIAS_SF BIAS_SF VDD VDD) pch_mac l=l_M1 w=w_M1_per_finger*nf_M1 multi=10 nf=nf_M1 sigma=1 mismatchflag=1
    M21 (STB_Y EA_BIAS_P VFB VFB) pch_mac l=l_M21 w=w_M21_per_finger*nf_M21 multi=8 nf=nf_M21 sigma=1 mismatchflag=1
    M17 (VOUT net08 VDD VDD) pch_mac l=l_M17 w=w_M17_per_finger*nf_M17 multi=120 nf=nf_M17 sigma=1 mismatchflag=1
    M45 (net0146 EA_BIAS_P net074 VDD) pch_hvt_mac l=200n w=1.5u multi=2 nf=1 sigma=1 mismatchflag=1
    M44 (net067 EA_BIAS_N net074 VDD) pch_hvt_mac l=200n w=1.5u multi=2 nf=1 sigma=1 mismatchflag=1
    M68 (net057 net057 VDD VDD) pch_25_mac l=l_M68 w=w_M68_per_finger*nf_M68 multi=1 nf=nf_M68 sigma=1 mismatchflag=1
    M56 (net065 net065 VDD VDD) pch_25_mac l=l_M56 w=w_M56_per_finger*nf_M56 multi=2 nf=nf_M56 sigma=1 mismatchflag=1
    M55 (EA_BIAS_N net065 VDD VDD) pch_25_mac l=l_M55 w=w_M55_per_finger*nf_M55 multi=2 nf=nf_M55 sigma=1 mismatchflag=1
    M34 (VB1 VB1 VDD VDD) pch_25_mac l=l_M34 w=w_M34_per_finger*nf_M34 multi=1 nf=nf_M34 sigma=1 mismatchflag=1
    M29 (net0116 EA_BIAS_P net076 net076) pch_25_mac l=l_M29 w=w_M29_per_finger*nf_M29 multi=1 nf=nf_M29 sigma=1 mismatchflag=1
    M27 (net0118 net031 net076 net076) pch_25_mac l=l_M27 w=w_M27_per_finger*nf_M27 multi=1 nf=nf_M27 sigma=1 mismatchflag=1
    M85 (net0150 VB net0152 net0152) nch_mac l=l_M85 w=w_M85_per_finger*nf_M85 multi=2 nf=nf_M85 sigma=1 mismatchflag=1
    M86 (net0159 VB net0228 net0228) nch_mac l=l_M86 w=w_M86_per_finger*nf_M86 multi=2 nf=nf_M86 sigma=1 mismatchflag=1
    M46 (net053 net031 EA_BIAS_N net053) nch_mac l=l_M46 w=w_M46_per_finger*nf_M46 multi=1 nf=nf_M46 sigma=1 mismatchflag=1
    M38 (net083 net083 GND GND) nch_mac l=l_M38 w=w_M38_per_finger*nf_M38 multi=1 nf=nf_M38 sigma=1 mismatchflag=1
    M37 (net080 net083 GND GND) nch_mac l=l_M37 w=w_M37_per_finger*nf_M37 multi=2 nf=nf_M37 sigma=1 mismatchflag=1
    M24 (net073 VB2 net0117 GND) nch_mac l=l_M24 w=w_M24_per_finger*nf_M24 multi=1 nf=nf_M24 sigma=1 mismatchflag=1
    M23 (net079 VB2 net0115 GND) nch_mac l=l_M23 w=w_M23_per_finger*nf_M23 multi=1 nf=nf_M23 sigma=1 mismatchflag=1
    M2 (net06 V2 VOUT1 net06) nch_mac l=l_M2 w=w_M2_per_finger*nf_M2 multi=1 nf=nf_M2 sigma=1 mismatchflag=1
    M4 (BIAS BIAS GND GND) nch_mac l=l_M4 w=w_M4_per_finger*nf_M4 multi=2 nf=nf_M4 sigma=1 mismatchflag=1
    M6 (net024 BIAS GND GND) nch_mac l=l_M6 w=w_M6_per_finger*nf_M6 multi=2 nf=nf_M6 sigma=1 mismatchflag=1
    M10 (BIAS_EA_CAP BIAS GND GND) nch_mac l=l_M10 w=w_M10_per_finger*nf_M10 multi=2 nf=nf_M10 sigma=1 mismatchflag=1
    M5 (BIAS_VIN_INV BIAS GND GND) nch_mac l=l_M5 w=w_M5_per_finger*nf_M5 multi=2 nf=nf_M5 sigma=1 mismatchflag=1
    M7 (BIAS_EA_RFC BIAS GND GND) nch_mac l=l_M7 w=w_M7_per_finger*nf_M7 multi=10 nf=nf_M7 sigma=1 mismatchflag=1
ends LDO_CORE
// LDO_OPT_LouFM/tb_Trans/schematic
C0 (VOUT GND_OFFCHIP) capacitor c=CLOAD
I5 (BIAS_CAP GND_OFFCHIP) isource dc=BIAS_CAP type=dc
I4 (BIAS_SF GND_OFFCHIP) isource dc=BIAS_SF type=dc
I3 (VDD_OFFCHIP BIAS) isource dc=BIAS type=dc
V5 (GND GND_OFFCHIP) vsource dc=0 type=dc
V4 (VDD VDD_OFFCHIP) vsource dc=0 type=dc
V3 (VREF GND_OFFCHIP) vsource dc=1 type=dc
V1 (VDD_OFFCHIP GND_OFFCHIP) vsource dc=VIN mag=VIN_AC type=dc
V0 (GND_OFFCHIP 0) vsource dc=0 type=dc
IPRB0 (STB_X net02) iprobe
I6 (VOUT GND_OFFCHIP) isource type=pulse val0=500u val1=300m period=60u delay=1u rise=10n fall=10n width=10u
I0 (BIAS BIAS_CAP BIAS_SF GND STB_X net02 VDD VOUT VOUT VREF) LDO_CORE
simulatorOptions options temp=27
tran tran stop=40u errpreset=conservative
save I6:sink
