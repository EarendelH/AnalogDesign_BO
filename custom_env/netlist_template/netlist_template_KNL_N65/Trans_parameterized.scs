// Design: LDO_JSSC_KaNangLeung/tb_Trans
simulator lang=spectre
global 0
parameters CF1 CM1 CM2 RF1 RF2 VB1 VB2 VB4 w_M0_per_finger l_M0 nf_M0 w_M24_per_finger l_M24 nf_M24 w_M23_per_finger l_M23 nf_M23 w_M47_per_finger l_M47 nf_M47 w_M46_per_finger l_M46 nf_M46 w_M45_per_finger l_M45 nf_M45 w_M13_per_finger l_M13 nf_M13 w_M12_per_finger l_M12 nf_M12 w_M16_per_finger l_M16 nf_M16 w_M11_per_finger l_M11 nf_M11 w_M22_per_finger l_M22 nf_M22 w_M21_per_finger l_M21 nf_M21 w_M42_per_finger l_M42 nf_M42 w_M43_per_finger l_M43 nf_M43 w_M44_per_finger l_M44 nf_M44 w_M41_per_finger l_M41 nf_M41 w_M18_per_finger l_M18 nf_M18 w_M17_per_finger l_M17 nf_M17 w_M14_per_finger l_M14 nf_M14 w_M15_per_finger l_M15 nf_M15
include "/data/PDK/pdk_installed/tsmc65_gp/tsmcN65/../models/spectre/crn65gplus_2d5_lk_v1d0.scs" section=tt_bip
include "/data/PDK/pdk_installed/tsmc65_gp/tsmcN65/../models/spectre/crn65gplus_2d5_lk_v1d0.scs" section=tt_dio
include "/data/PDK/pdk_installed/tsmc65_gp/tsmcN65/../models/spectre/crn65gplus_2d5_lk_v1d0.scs" section=tt_dio_33
include "/data/PDK/pdk_installed/tsmc65_gp/tsmcN65/../models/spectre/crn65gplus_2d5_lk_v1d0.scs" section=tt_mim
include "/data/PDK/pdk_installed/tsmc65_gp/tsmcN65/../models/spectre/crn65gplus_2d5_lk_v1d0.scs" section=tt_dio_dnw
include "/data/PDK/pdk_installed/tsmc65_gp/tsmcN65/../models/spectre/crn65gplus_2d5_lk_v1d0.scs" section=tt_dio_18
include "/data/PDK/pdk_installed/tsmc65_gp/tsmcN65/../models/spectre/crn65gplus_2d5_lk_v1d0.scs" section=tt_bip_npn
include "/data/PDK/pdk_installed/tsmc65_gp/tsmcN65/../models/spectre/crn65gplus_2d5_lk_v1d0.scs" section=tt_33
include "/data/PDK/pdk_installed/tsmc65_gp/tsmcN65/../models/spectre/crn65gplus_2d5_lk_v1d0.scs" section=tt_rfrtmom
include "/data/PDK/pdk_installed/tsmc65_gp/tsmcN65/../models/spectre/crn65gplus_2d5_lk_v1d0.scs" section=tt_mos_cap_25
include "/data/PDK/pdk_installed/tsmc65_gp/tsmcN65/../models/spectre/crn65gplus_2d5_lk_v1d0.scs" section=tt_18
include "/data/PDK/pdk_installed/tsmc65_gp/tsmcN65/../models/spectre/crn65gplus_2d5_lk_v1d0.scs" section=tt_disres
include "/data/PDK/pdk_installed/tsmc65_gp/tsmcN65/../models/spectre/crn65gplus_2d5_lk_v1d0.scs" section=tt_res
include "/data/PDK/pdk_installed/tsmc65_gp/tsmcN65/../models/spectre/crn65gplus_2d5_lk_v1d0.scs" section=tt_dio_na
include "/data/PDK/pdk_installed/tsmc65_gp/tsmcN65/../models/spectre/crn65gplus_2d5_lk_v1d0.scs" section=tt_rfmos_33
include "/data/PDK/pdk_installed/tsmc65_gp/tsmcN65/../models/spectre/crn65gplus_2d5_lk_v1d0.scs" section=tt_dio_hvt
include "/data/PDK/pdk_installed/tsmc65_gp/tsmcN65/../models/spectre/crn65gplus_2d5_lk_v1d0.scs" section=tt_rfmvar
include "/data/PDK/pdk_installed/tsmc65_gp/tsmcN65/../models/spectre/crn65gplus_2d5_lk_v1d0.scs" section=tt_rfmos_18
include "/data/PDK/pdk_installed/tsmc65_gp/tsmcN65/../models/spectre/crn65gplus_2d5_lk_v1d0.scs" section=tt_na
include "/data/PDK/pdk_installed/tsmc65_gp/tsmcN65/../models/spectre/crn65gplus_2d5_lk_v1d0.scs" section=tt_dio_na33
include "/data/PDK/pdk_installed/tsmc65_gp/tsmcN65/../models/spectre/crn65gplus_2d5_lk_v1d0.scs" section=tt_dio_lvt
include "/data/PDK/pdk_installed/tsmc65_gp/tsmcN65/../models/spectre/crn65gplus_2d5_lk_v1d0.scs" section=tt_rfres_sa
include "/data/PDK/pdk_installed/tsmc65_gp/tsmcN65/../models/spectre/crn65gplus_2d5_lk_v1d0.scs" section=tt_na33
include "/data/PDK/pdk_installed/tsmc65_gp/tsmcN65/../models/spectre/crn65gplus_2d5_lk_v1d0.scs" section=tt_dio_esd
include "/data/PDK/pdk_installed/tsmc65_gp/tsmcN65/../models/spectre/crn65gplus_2d5_lk_v1d0.scs" section=tt_rfmim
include "/data/PDK/pdk_installed/tsmc65_gp/tsmcN65/../models/spectre/crn65gplus_2d5_lk_v1d0.scs" section=tt_dio_25od33
include "/data/PDK/pdk_installed/tsmc65_gp/tsmcN65/../models/spectre/crn65gplus_2d5_lk_v1d0.scs" section=tt_25od33
include "/data/PDK/pdk_installed/tsmc65_gp/tsmcN65/../models/spectre/crn65gplus_2d5_lk_v1d0.scs" section=tt
include "/data/PDK/pdk_installed/tsmc65_gp/tsmcN65/../models/spectre/crn65gplus_2d5_lk_v1d0.scs" section=tt_mos_cap
include "/data/PDK/pdk_installed/tsmc65_gp/tsmcN65/../models/spectre/crn65gplus_2d5_lk_v1d0.scs" section=tt_dio_25
include "/data/PDK/pdk_installed/tsmc65_gp/tsmcN65/../models/spectre/crn65gplus_2d5_lk_v1d0.scs" section=tt_dio_25ud18
include "/data/PDK/pdk_installed/tsmc65_gp/tsmcN65/../models/spectre/crn65gplus_2d5_lk_v1d0.scs" section=tt_25
include "/data/PDK/pdk_installed/tsmc65_gp/tsmcN65/../models/spectre/crn65gplus_2d5_lk_v1d0.scs" section=tt_rfmos
include "/data/PDK/pdk_installed/tsmc65_gp/tsmcN65/../models/spectre/crn65gplus_2d5_lk_v1d0.scs" section=tt_25ud18
include "/data/PDK/pdk_installed/tsmc65_gp/tsmcN65/../models/spectre/crn65gplus_2d5_lk_v1d0.scs" section=tt_dio_na25od33
include "/data/PDK/pdk_installed/tsmc65_gp/tsmcN65/../models/spectre/crn65gplus_2d5_lk_v1d0.scs" section=tt_rfjvar
include "/data/PDK/pdk_installed/tsmc65_gp/tsmcN65/../models/spectre/crn65gplus_2d5_lk_v1d0.scs" section=tt_rfmos_25
include "/data/PDK/pdk_installed/tsmc65_gp/tsmcN65/../models/spectre/crn65gplus_2d5_lk_v1d0.scs" section=tt_rtmom
include "/data/PDK/pdk_installed/tsmc65_gp/tsmcN65/../models/spectre/crn65gplus_2d5_lk_v1d0.scs" section=tt_na25od33
include "/data/PDK/pdk_installed/tsmc65_gp/tsmcN65/../models/spectre/crn65gplus_2d5_lk_v1d0.scs" section=tt_dio_na25
include "/data/PDK/pdk_installed/tsmc65_gp/tsmcN65/../models/spectre/crn65gplus_2d5_lk_v1d0.scs" section=tt_rfres_rpo
include "/data/PDK/pdk_installed/tsmc65_gp/tsmcN65/../models/spectre/crn65gplus_2d5_lk_v1d0.scs" section=tt_hvt
include "/data/PDK/pdk_installed/tsmc65_gp/tsmcN65/../models/spectre/crn65gplus_2d5_lk_v1d0.scs" section=tt_rfind
include "/data/PDK/pdk_installed/tsmc65_gp/tsmcN65/../models/spectre/crn65gplus_2d5_lk_v1d0.scs" section=tt_rfmvar_25
include "/data/PDK/pdk_installed/tsmc65_gp/tsmcN65/../models/spectre/crn65gplus_2d5_lk_v1d0.scs" section=tt_na25
include "/data/PDK/pdk_installed/tsmc65_gp/tsmcN65/../models/spectre/crn65gplus_2d5_lk_v1d0.scs" section=tt_lvt
// LDO_JSSC_KaNangLeung/LDO_Core/schematic
subckt LDO_Core VB1 VB2 VB4 VFB_IN VFB_OUT VIN VOUT VREF VSS
    M0 (VOUT net33 VIN VIN) pch_mac l=l_M0 w=w_M0_per_finger*1 multi=nf_M0 nf=1 sigma=1 mismatchflag=1
    M24 (net33 net31 VIN VIN) pch_mac l=l_M24 w=w_M24_per_finger*nf_M24 multi=1 nf=nf_M24 sigma=1 mismatchflag=1
    M23 (net31 net31 VIN VIN) pch_mac l=l_M23 w=w_M23_per_finger*nf_M23 multi=1 nf=nf_M23 sigma=1 mismatchflag=1
    M47 (net42 net42 VIN VIN) pch_mac l=l_M47 w=w_M47_per_finger*nf_M47 multi=1 nf=nf_M47 sigma=1 mismatchflag=1
    M46 (net22 net22 VIN VIN) pch_mac l=l_M46 w=w_M46_per_finger*nf_M46 multi=1 nf=nf_M46 sigma=1 mismatchflag=1
    M45 (net20 net22 VIN VIN) pch_mac l=l_M45 w=w_M45_per_finger*nf_M45 multi=1 nf=nf_M45 sigma=1 mismatchflag=1
    M13 (net14 VREF net11 VIN) pch_mac l=l_M13 w=w_M13_per_finger*nf_M13 multi=1 nf=nf_M13 sigma=1 mismatchflag=1
    M12 (net9 VFB_IN net11 VIN) pch_mac l=l_M12 w=w_M12_per_finger*nf_M12 multi=1 nf=nf_M12 sigma=1 mismatchflag=1
    M16 (net15 VB1 VIN VIN) pch_mac l=l_M16 w=w_M16_per_finger*nf_M16 multi=1 nf=nf_M16 sigma=1 mismatchflag=1
    M11 (net11 VB1 VIN VIN) pch_mac l=l_M11 w=w_M11_per_finger*nf_M11 multi=1 nf=nf_M11 sigma=1 mismatchflag=1
    M22 (net33 net15 VSS VSS) nch_mac l=l_M22 w=w_M22_per_finger*nf_M22 multi=1 nf=nf_M22 sigma=1 mismatchflag=1
    M21 (net31 net14 VSS VSS) nch_mac l=l_M21 w=w_M21_per_finger*nf_M21 multi=1 nf=nf_M21 sigma=1 mismatchflag=1
    M42 (net25 VB2 VSS VSS) nch_mac l=l_M42 w=w_M42_per_finger*nf_M42 multi=1 nf=nf_M42 sigma=1 mismatchflag=1
    M43 (net42 net20 net25 VSS) nch_mac l=l_M43 w=w_M43_per_finger*nf_M43 multi=1 nf=nf_M43 sigma=1 mismatchflag=1
    M44 (net22 VB4 net25 VSS) nch_mac l=l_M44 w=w_M44_per_finger*nf_M44 multi=1 nf=nf_M44 sigma=1 mismatchflag=1
    M41 (net20 net14 VSS VSS) nch_mac l=l_M41 w=w_M41_per_finger*nf_M41 multi=1 nf=nf_M41 sigma=1 mismatchflag=1
    M18 (net15 net15 VSS VSS) nch_mac l=l_M18 w=w_M18_per_finger*nf_M18 multi=1 nf=nf_M18 sigma=1 mismatchflag=1
    M17 (net15 net14 VSS VSS) nch_mac l=l_M17 w=w_M17_per_finger*nf_M17 multi=1 nf=nf_M17 sigma=1 mismatchflag=1
    M14 (net9 net9 VSS VSS) nch_mac l=l_M14 w=w_M14_per_finger*nf_M14 multi=1 nf=nf_M14 sigma=1 mismatchflag=1
    M15 (net14 net9 VSS VSS) nch_mac l=l_M15 w=w_M15_per_finger*nf_M15 multi=1 nf=nf_M15 sigma=1 mismatchflag=1
    C3 (VOUT VFB_OUT) capacitor c=CF1
    C1 (net14 VOUT) capacitor c=CM1
    C2 (net14 net20) capacitor c=CM2
    R2 (VFB_OUT VSS) resistor r=RF2
    R1 (VOUT VFB_OUT) resistor r=RF1
ends LDO_Core
// LDO_JSSC_KaNangLeung/tb_Trans/schematic
C0 (VOUT VSS) capacitor c=10p
I1 (VOUT VSS) isource type=pulse val0=1m val1=100m period=10u delay=5u rise=100n fall=100n width=5u
V5 (VB4 0) vsource dc=VB4 type=dc
V4 (VB2 0) vsource dc=VB2 type=dc
V3 (VB1 0) vsource dc=VB1 type=dc
V2 (VIN 0) vsource dc=1.2 type=dc
V1 (VREF 0) vsource dc=1 type=dc
V0 (VSS 0) vsource dc=0 type=dc
I0 (VB1 VB2 VB4 VFB VFB VIN VOUT VREF VSS) LDO_Core
simulatorOptions options temp=27
tran tran stop=15u errpreset=conservative
