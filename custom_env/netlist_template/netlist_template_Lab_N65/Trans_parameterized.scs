// Design: LDO_Lab/tb_Trans
simulator lang=spectre
global 0
parameters CL=300p IBN=1.0u C1 CB CF R1 w_M19_per_finger l_M19 nf_M19 w_M0_per_finger l_M0 nf_M0 w_M18_per_finger l_M18 nf_M18 w_M17_per_finger l_M17 nf_M17 w_M16_per_finger l_M16 nf_M16 w_M15_per_finger l_M15 nf_M15 w_M7_per_finger l_M7 nf_M7 w_M8_per_finger l_M8 nf_M8 w_M9_per_finger l_M9 nf_M9 w_M5_per_finger l_M5 nf_M5 w_M10_per_finger l_M10 nf_M10 w_M6_per_finger l_M6 nf_M6 w_M4_per_finger l_M4 nf_M4 w_M3_per_finger l_M3 nf_M3 w_M1_per_finger l_M1 nf_M1 w_M2_per_finger l_M2 nf_M2 w_M13_per_finger l_M13 nf_M13 w_M12_per_finger l_M12 nf_M12 w_M14_per_finger l_M14 nf_M14 w_M11_per_finger l_M11 nf_M11
include "/data/PDK/pdk_installed/hlmc55_hv_6v/pdk/HLMC_HV055GE_MV6V_CDS_OA_V1P1/hlmc55hv/../models/spectre/HLMC_55HV_V1P1_CORNER.LIB" section=TT
include "/data/PDK/pdk_installed/hlmc55_hv_6v/pdk/HLMC_HV055GE_MV6V_CDS_OA_V1P1/hlmc55hv/../models/spectre/HLMC_55HV_V1P1_CORNER.LIB" section=DIO_ALL_TT
include "/data/PDK/pdk_installed/hlmc55_hv_6v/pdk/HLMC_HV055GE_MV6V_CDS_OA_V1P1/hlmc55hv/../models/spectre/HLMC_55HV_V1P1_CORNER.LIB" section=BJT_ALL_TT
include "/data/PDK/pdk_installed/hlmc55_hv_6v/pdk/HLMC_HV055GE_MV6V_CDS_OA_V1P1/hlmc55hv/../models/spectre/HLMC_55HV_V1P1_CORNER.LIB" section=RES_ALL_TT
include "/data/PDK/pdk_installed/hlmc55_hv_6v/pdk/HLMC_HV055GE_MV6V_CDS_OA_V1P1/hlmc55hv/../models/spectre/HLMC_55HV_V1P1_CORNER.LIB" section=VAR_ALL_TT
include "/data/PDK/pdk_installed/hlmc55_hv_6v/pdk/HLMC_HV055GE_MV6V_CDS_OA_V1P1/hlmc55hv/../models/spectre/HLMC_55HV_V1P1_CORNER.LIB" section=MOM_ALL_TT
// LDO_Lab/LDO_Core/schematic
subckt LDO_Core IBN_CORE VF1 VF2 VFB VIN VOUT VREF VSS
    M19 (VF1 VSET VOUT VOUT) plvt12 w=((w_M19_per_finger) * (nf_M19)) l=l_M19 nf=nf_M19 multi=(1) global_flag=0 flag_cpc=1
    M0 (VOUT VG VIN VIN) plvt12 w=((w_M0_per_finger) * (1)) l=l_M0 nf=1 multi=(nf_M0) global_flag=0 flag_cpc=1
    M18 (net04 net04 VIN VIN) p12 w=((w_M18_per_finger) * (nf_M18)) l=l_M18 nf=nf_M18 multi=(1) global_flag=0 flag_cpc=1
    M17 (VG VG VIN VIN) p12 w=((w_M17_per_finger) * (nf_M17)) l=l_M17 nf=nf_M17 multi=(1) global_flag=0 flag_cpc=1
    M16 (net042 VF2 VG VG) p12 w=((w_M16_per_finger) * (nf_M16)) l=l_M16 nf=nf_M16 multi=(1) global_flag=0 flag_cpc=1
    M15 (VG net04 VIN VIN) p12 w=((w_M15_per_finger) * (nf_M15)) l=l_M15 nf=nf_M15 multi=(1) global_flag=0 flag_cpc=1
    M7 (net073 net073 VIN VIN) p6ud33io w=((w_M7_per_finger) * (nf_M7)) l=l_M7 nf=nf_M7 multi=(1) global_flag=0
    M8 (V1 net073 VIN VIN) p6ud33io w=((w_M8_per_finger) * (nf_M8)) l=l_M8 nf=nf_M8 multi=(1) global_flag=0
    M9 (V2 V1 VIN VIN) p6ud33io w=((w_M9_per_finger) * (nf_M9)) l=l_M9 nf=nf_M9 multi=(1) global_flag=0
    M5 (VSET net073 VIN VIN) p6ud33io w=((w_M5_per_finger) * (nf_M5)) l=l_M5 nf=nf_M5 multi=(1) global_flag=0
    R1 (net040 IBN_CORE) resistor r=R1
    C1 (VOUT net040) capacitor c=C1
    CL (VOUT VSS) capacitor c=CL
    CB (VSET VSS) capacitor c=CB
    CF (VOUT VF1) capacitor c=CF
    M10 (V1 VFB net060 VSS) n6ud33io w=((w_M10_per_finger) * (nf_M10)) l=l_M10 nf=nf_M10 multi=(1) global_flag=0
    M6 (net073 VREF net060 VSS) n6ud33io w=((w_M6_per_finger) * (nf_M6)) l=l_M6 nf=nf_M6 multi=(1) global_flag=0
    M4 (V2 V2 VSS VSS) n6ud33io w=((w_M4_per_finger) * (nf_M4)) l=l_M4 nf=nf_M4 multi=(1) global_flag=0
    M3 (VSET V2 VSS VSS) n6ud33io w=((w_M3_per_finger) * (nf_M3)) l=l_M3 nf=nf_M3 multi=(1) global_flag=0
    M1 (net060 IBN_CORE VSS VSS) n6ud33io w=((w_M1_per_finger) * (nf_M1)) l=l_M1 nf=nf_M1 multi=(1) global_flag=0
    M2 (VG net042 VSS VSS) n6ud33io w=((w_M2_per_finger) * (nf_M2)) l=l_M2 nf=nf_M2 multi=(1) global_flag=0
    M13 (net04 net040 VSS VSS) n6ud33io w=((w_M13_per_finger) * (nf_M13)) l=l_M13 nf=nf_M13 multi=(1) global_flag=0
    M12 (net042 IBN_CORE VSS VSS) n6ud33io w=((w_M12_per_finger) * (nf_M12)) l=l_M12 nf=nf_M12 multi=(1) global_flag=0
    M14 (IBN_CORE IBN_CORE VSS VSS) n6ud33io w=((w_M14_per_finger) * (nf_M14)) l=l_M14 nf=nf_M14 multi=(1) global_flag=0
    M11 (VF1 IBN_CORE VSS VSS) n6ud33io w=((w_M11_per_finger) * (nf_M11)) l=l_M11 nf=nf_M11 multi=(1) global_flag=0
ends LDO_Core
// LDO_Lab/tb_Trans/schematic
I0 (IBN_CORE net02 net02 VOUT VIN VOUT VREF VSS) LDO_Core
V3 (net4 0) vsource dc=1.8 type=dc
V2 (VREF 0) vsource dc=1.2 type=dc
V1 (VIN 0) vsource dc=1.8 type=dc
V0 (VSS 0) vsource type=dc
I2 (net4 IBN_CORE) isource dc=IBN type=dc
I1 (VOUT VSS) isource type=pulse val0=500.0u val1=50m period=10u delay=5u rise=2n fall=2n width=5u
simulatorOptions options temp=27
tran tran stop=15u errpreset=conservative
save I1:sink
