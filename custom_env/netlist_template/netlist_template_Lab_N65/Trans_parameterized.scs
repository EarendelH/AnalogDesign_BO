// Design: LDO_Lab/tb_Trans
simulator lang=spectre
global 0
parameters C1 C2 C3 IB w_M11_per_finger l_M11 nf_M11 w_M3_per_finger l_M3 nf_M3 w_M5_per_finger l_M5 nf_M5 w_M6_per_finger l_M6 nf_M6 w_M1_per_finger l_M1 nf_M1 w_M4_per_finger l_M4 nf_M4 w_M14_per_finger l_M14 nf_M14 w_M15_per_finger l_M15 nf_M15 w_M12_per_finger l_M12 nf_M12 w_M2_per_finger l_M2 nf_M2 w_M13_per_finger l_M13 nf_M13 w_M10_per_finger l_M10 nf_M10 w_M9_per_finger l_M9 nf_M9 w_M8_per_finger l_M8 nf_M8 w_M7_per_finger l_M7 nf_M7 w_M20_per_finger l_M20 nf_M20 w_M0_per_finger l_M0 nf_M0 w_M19_per_finger l_M19 nf_M19 w_M18_per_finger l_M18 nf_M18 w_M17_per_finger l_M17 nf_M17 w_M16_per_finger l_M16 nf_M16
include "/home/students/wuhan/spectre_N65/crn65gplus_2d5_lk_v1d0.scs" section=tt_bip
include "/home/students/wuhan/spectre_N65/crn65gplus_2d5_lk_v1d0.scs" section=tt_dio
include "/home/students/wuhan/spectre_N65/crn65gplus_2d5_lk_v1d0.scs" section=tt_dio_33
include "/home/students/wuhan/spectre_N65/crn65gplus_2d5_lk_v1d0.scs" section=tt_mim
include "/home/students/wuhan/spectre_N65/crn65gplus_2d5_lk_v1d0.scs" section=tt_dio_dnw
include "/home/students/wuhan/spectre_N65/crn65gplus_2d5_lk_v1d0.scs" section=tt_dio_18
include "/home/students/wuhan/spectre_N65/crn65gplus_2d5_lk_v1d0.scs" section=tt_bip_npn
include "/home/students/wuhan/spectre_N65/crn65gplus_2d5_lk_v1d0.scs" section=tt_33
include "/home/students/wuhan/spectre_N65/crn65gplus_2d5_lk_v1d0.scs" section=tt_rfrtmom
include "/home/students/wuhan/spectre_N65/crn65gplus_2d5_lk_v1d0.scs" section=tt_mos_cap_25
include "/home/students/wuhan/spectre_N65/crn65gplus_2d5_lk_v1d0.scs" section=tt_18
include "/home/students/wuhan/spectre_N65/crn65gplus_2d5_lk_v1d0.scs" section=tt_disres
include "/home/students/wuhan/spectre_N65/crn65gplus_2d5_lk_v1d0.scs" section=tt_res
include "/home/students/wuhan/spectre_N65/crn65gplus_2d5_lk_v1d0.scs" section=tt_dio_na
include "/home/students/wuhan/spectre_N65/crn65gplus_2d5_lk_v1d0.scs" section=tt_rfmos_33
include "/home/students/wuhan/spectre_N65/crn65gplus_2d5_lk_v1d0.scs" section=tt_dio_hvt
include "/home/students/wuhan/spectre_N65/crn65gplus_2d5_lk_v1d0.scs" section=tt_rfmvar
include "/home/students/wuhan/spectre_N65/crn65gplus_2d5_lk_v1d0.scs" section=tt_rfmos_18
include "/home/students/wuhan/spectre_N65/crn65gplus_2d5_lk_v1d0.scs" section=tt_na
include "/home/students/wuhan/spectre_N65/crn65gplus_2d5_lk_v1d0.scs" section=tt_dio_na33
include "/home/students/wuhan/spectre_N65/crn65gplus_2d5_lk_v1d0.scs" section=tt_dio_lvt
include "/home/students/wuhan/spectre_N65/crn65gplus_2d5_lk_v1d0.scs" section=tt_rfres_sa
include "/home/students/wuhan/spectre_N65/crn65gplus_2d5_lk_v1d0.scs" section=tt_na33
include "/home/students/wuhan/spectre_N65/crn65gplus_2d5_lk_v1d0.scs" section=tt_dio_esd
include "/home/students/wuhan/spectre_N65/crn65gplus_2d5_lk_v1d0.scs" section=tt_rfmim
include "/home/students/wuhan/spectre_N65/crn65gplus_2d5_lk_v1d0.scs" section=tt_dio_25od33
include "/home/students/wuhan/spectre_N65/crn65gplus_2d5_lk_v1d0.scs" section=tt_25od33
include "/home/students/wuhan/spectre_N65/crn65gplus_2d5_lk_v1d0.scs" section=tt
include "/home/students/wuhan/spectre_N65/crn65gplus_2d5_lk_v1d0.scs" section=tt_mos_cap
include "/home/students/wuhan/spectre_N65/crn65gplus_2d5_lk_v1d0.scs" section=tt_dio_25
include "/home/students/wuhan/spectre_N65/crn65gplus_2d5_lk_v1d0.scs" section=tt_dio_25ud18
include "/home/students/wuhan/spectre_N65/crn65gplus_2d5_lk_v1d0.scs" section=tt_25
include "/home/students/wuhan/spectre_N65/crn65gplus_2d5_lk_v1d0.scs" section=tt_rfmos
include "/home/students/wuhan/spectre_N65/crn65gplus_2d5_lk_v1d0.scs" section=tt_25ud18
include "/home/students/wuhan/spectre_N65/crn65gplus_2d5_lk_v1d0.scs" section=tt_dio_na25od33
include "/home/students/wuhan/spectre_N65/crn65gplus_2d5_lk_v1d0.scs" section=tt_rfjvar
include "/home/students/wuhan/spectre_N65/crn65gplus_2d5_lk_v1d0.scs" section=tt_rfmos_25
include "/home/students/wuhan/spectre_N65/crn65gplus_2d5_lk_v1d0.scs" section=tt_rtmom
include "/home/students/wuhan/spectre_N65/crn65gplus_2d5_lk_v1d0.scs" section=tt_na25od33
include "/home/students/wuhan/spectre_N65/crn65gplus_2d5_lk_v1d0.scs" section=tt_dio_na25
include "/home/students/wuhan/spectre_N65/crn65gplus_2d5_lk_v1d0.scs" section=tt_rfres_rpo
include "/home/students/wuhan/spectre_N65/crn65gplus_2d5_lk_v1d0.scs" section=tt_hvt
include "/home/students/wuhan/spectre_N65/crn65gplus_2d5_lk_v1d0.scs" section=tt_rfind
include "/home/students/wuhan/spectre_N65/crn65gplus_2d5_lk_v1d0.scs" section=tt_rfmvar_25
include "/home/students/wuhan/spectre_N65/crn65gplus_2d5_lk_v1d0.scs" section=tt_na25
include "/home/students/wuhan/spectre_N65/crn65gplus_2d5_lk_v1d0.scs" section=tt_lvt
// LDO_Lab/LDO_Core/schematic
subckt LDO_Core IBN_OTA VFB_IN VFB_OUT VIN VOUT VREF VSS
    M11 (VSET V2 VSS VSS) nch_mac l=l_M11 w=w_M11_per_finger*nf_M11 multi=1 nf=nf_M11 sigma=1 mismatchflag=1
    M3 (V2 V2 VSS VSS) nch_mac l=l_M3 w=w_M3_per_finger*nf_M3 multi=1 nf=nf_M3 sigma=1 mismatchflag=1
    M5 (net99 VREF net100 VSS) nch_mac l=l_M5 w=w_M5_per_finger*nf_M5 multi=1 nf=nf_M5 sigma=1 mismatchflag=1
    M6 (net101 VOUT net100 VSS) nch_mac l=l_M6 w=w_M6_per_finger*nf_M6 multi=1 nf=nf_M6 sigma=1 mismatchflag=1
    M1 (net100 IBN_OTA VSS VSS) nch_mac l=l_M1 w=w_M1_per_finger*nf_M1 multi=1 nf=nf_M1 sigma=1 mismatchflag=1
    M4 (IBN_OTA IBN_OTA VSS VSS) nch_mac l=l_M4 w=w_M4_per_finger*nf_M4 multi=1 nf=nf_M4 sigma=1 mismatchflag=1
    M14 (net85 IBN1_1U VSS VSS) nch_mac l=l_M14 w=w_M14_per_finger*nf_M14 multi=1 nf=nf_M14 sigma=1 mismatchflag=1
    M15 (net84 net83 VSS VSS) nch_mac l=l_M15 w=w_M15_per_finger*nf_M15 multi=1 nf=nf_M15 sigma=1 mismatchflag=1
    M12 (VFB_OUT IBN1_1U VSS VSS) nch_mac l=l_M12 w=w_M12_per_finger*nf_M12 multi=1 nf=nf_M12 sigma=1 mismatchflag=1
    M2 (VG net85 VSS VSS) nch_mac l=l_M2 w=w_M2_per_finger*nf_M2 multi=1 nf=nf_M2 sigma=1 mismatchflag=1
    M13 (IBN1_1U IBN1_1U VSS VSS) nch_mac l=l_M13 w=w_M13_per_finger*nf_M13 multi=1 nf=nf_M13 sigma=1 mismatchflag=1
    M10 (V2 net101 VIN VIN) pch_mac l=l_M10 w=w_M10_per_finger*nf_M10 multi=1 nf=nf_M10 sigma=1 mismatchflag=1
    M9 (net101 net99 VIN VIN) pch_mac l=l_M9 w=w_M9_per_finger*nf_M9 multi=1 nf=nf_M9 sigma=1 mismatchflag=1
    M8 (VSET net99 VIN VIN) pch_mac l=l_M8 w=w_M8_per_finger*nf_M8 multi=1 nf=nf_M8 sigma=1 mismatchflag=1
    M7 (net99 net99 VIN VIN) pch_mac l=l_M7 w=w_M7_per_finger*nf_M7 multi=1 nf=nf_M7 sigma=1 mismatchflag=1
    M20 (VFB_OUT VSET VOUT VOUT) pch_mac l=l_M20 w=w_M20_per_finger*nf_M20 multi=1 nf=nf_M20 sigma=1 mismatchflag=1
    M0 (VOUT VG VIN VIN) pch_mac l=l_M0 w=w_M0_per_finger*1 multi=nf_M0 nf=1 sigma=1 mismatchflag=1
    M19 (net84 net84 VIN VIN) pch_mac l=l_M19 w=w_M19_per_finger*nf_M19 multi=1 nf=nf_M19 sigma=1 mismatchflag=1
    M18 (VG VG VIN VIN) pch_mac l=l_M18 w=w_M18_per_finger*nf_M18 multi=1 nf=nf_M18 sigma=1 mismatchflag=1
    M17 (net85 VFB_IN VG VG) pch_mac l=l_M17 w=w_M17_per_finger*nf_M17 multi=1 nf=nf_M17 sigma=1 mismatchflag=1
    M16 (VG net84 VIN VIN) pch_mac l=l_M16 w=w_M16_per_finger*nf_M16 multi=1 nf=nf_M16 sigma=1 mismatchflag=1
    R6 (net83 IBN1_1U) resistor r=1M
    C1 (VOUT VFB_OUT) capacitor c=C1
    C2 (VSET VSS) capacitor c=C2
    C3 (VOUT net83) capacitor c=C3
ends LDO_Core
// LDO_Lab/tb_Trans/schematic
V3 (net5 0) vsource dc=1.2 type=dc
V2 (VIN 0) vsource dc=1.2 type=dc
V1 (VREF 0) vsource dc=1 type=dc
V0 (VSS 0) vsource dc=0 type=dc
C0 (VOUT VSS) capacitor c=10p
I2 (net5 IBN_OTA) isource dc=IB type=dc
I0 (IBN_OTA VFB VFB VIN VOUT VREF VSS) LDO_Core
I1 (VOUT VSS) isource type=pulse val0=1m val1=100m period=10u delay=5u rise=100n fall=100n width=5u
simulatorOptions options temp=27
tran tran stop=15u errpreset=conservative
