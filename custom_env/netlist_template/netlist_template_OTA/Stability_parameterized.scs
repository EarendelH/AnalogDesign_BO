// Design: OTA/tb_stability
simulator lang=spectre
global 0
parameters CLOAD IB R1 R2 w_M22_per_finger l_M22 nf_M22 w_M23_per_finger l_M23 nf_M23 w_M7_per_finger l_M7 nf_M7 w_M6_per_finger l_M6 nf_M6 w_M4_per_finger l_M4 nf_M4 w_M5_per_finger l_M5 nf_M5 w_M21_per_finger l_M21 nf_M21 w_M24_per_finger l_M24 nf_M24 w_M3_per_finger l_M3 nf_M3 w_M1_per_finger l_M1 nf_M1 w_M2_per_finger l_M2 nf_M2 w_M11_per_finger l_M11 nf_M11 w_M10_per_finger l_M10 nf_M10 w_M8_per_finger l_M8 nf_M8 w_M9_per_finger l_M9 nf_M9
include "/pdk/tsmc180bcd_g2/pdk/pdk_1p6m/models/spectre/c018bcd_gen2_v1d6_usage.scs" section=pre_simu
include "/pdk/tsmc180bcd_g2/pdk/pdk_1p6m/models/spectre/c018bcd_gen2_v1d6_usage.scs" section=tt_lib
// OTA/OPP/schematic
subckt OPP INN INP VDD VOUT VSS
    M22 (net040 net032 VDD VDD) pch_mac l=l_M22 w=w_M22_per_finger*nf_M22 multi=1 nf=nf_M22 sigma=1 mismatchflag=1
    M23 (net032 net010 net040 VDD) pch_mac l=l_M23 w=w_M23_per_finger*nf_M23 multi=1 nf=nf_M23 sigma=1 mismatchflag=1
    M7 (VOUT net010 net26 VDD) pch_mac l=l_M7 w=w_M7_per_finger*nf_M7 multi=1 nf=nf_M7 sigma=1 mismatchflag=1
    M6 (net018 net010 net28 VDD) pch_mac l=l_M6 w=w_M6_per_finger*nf_M6 multi=1 nf=nf_M6 sigma=1 mismatchflag=1
    M4 (net28 net032 VDD VDD) pch_mac l=l_M4 w=w_M4_per_finger*nf_M4 multi=1 nf=nf_M4 sigma=1 mismatchflag=1
    M5 (net26 net032 VDD VDD) pch_mac l=l_M5 w=w_M5_per_finger*nf_M5 multi=1 nf=nf_M5 sigma=1 mismatchflag=1
    M21 (net039 net05 VSS VSS) nch_mac l=l_M21 w=w_M21_per_finger*nf_M21 multi=1 nf=nf_M21 sigma=1 mismatchflag=1
    M24 (net010 net05 VSS VSS) nch_mac l=l_M24 w=w_M24_per_finger*nf_M24 multi=1 nf=nf_M24 sigma=1 mismatchflag=1
    M3 (net18 net05 VSS VSS) nch_mac l=l_M3 w=w_M3_per_finger*nf_M3 multi=1 nf=nf_M3 sigma=1 mismatchflag=1
    M1 (net28 INP net18 VSS) nch_mac l=l_M1 w=w_M1_per_finger*nf_M1 multi=1 nf=nf_M1 sigma=1 mismatchflag=1
    M2 (net26 INN net18 VSS) nch_mac l=l_M2 w=w_M2_per_finger*nf_M2 multi=1 nf=nf_M2 sigma=1 mismatchflag=1
    M11 (net035 net022 VSS VSS) nch_mac l=l_M11 w=w_M11_per_finger*nf_M11 multi=1 nf=nf_M11 sigma=1 mismatchflag=1
    M10 (net036 net022 VSS VSS) nch_mac l=l_M10 w=w_M10_per_finger*nf_M10 multi=1 nf=nf_M10 sigma=1 mismatchflag=1
    M8 (net022 net018 net036 VSS) nch_mac l=l_M8 w=w_M8_per_finger*nf_M8 multi=1 nf=nf_M8 sigma=1 mismatchflag=1
    M9 (VOUT net018 net035 VSS) nch_mac l=l_M9 w=w_M9_per_finger*nf_M9 multi=1 nf=nf_M9 sigma=1 mismatchflag=1
    IB (VDD net039) isource dc=IB type=dc
    R1 (net032 net010) resistor r=R1
    R2 (net018 net022) resistor r=R2
    CLOAD (VOUT VSS) capacitor c=CLOAD
ends OPP
// OTA/tb_stability/schematic
C1 (net3 0) capacitor c=1p
V4 (net4 0) vsource dc=900.0m mag=1 type=sine
IPRB1 (OUT net3) iprobe
I9 (net3 net4 net2 OUT 0) OPP
V1 (net2 0) vsource dc=1.8 type=dc
simulatorOptions options temp=27
dcOp dc
stb stb start=1 stop=1G probe=IPRB1 localgnd=0
