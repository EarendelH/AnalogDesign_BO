// Design: Buck/tb
simulator lang=spectre
global 0
parameters ILOAD=1 w_M45_per_finger l_M45 nf_M45 w_M46_per_finger l_M46 nf_M46 w_M47_per_finger l_M47 nf_M47 w_M48_per_finger l_M48 nf_M48 w_M41_per_finger l_M41 nf_M41 w_M42_per_finger l_M42 nf_M42 w_M43_per_finger l_M43 nf_M43 w_M44_per_finger l_M44 nf_M44 w_M15_per_finger l_M15 nf_M15 w_M14_per_finger l_M14 nf_M14 w_M11_per_finger l_M11 nf_M11 w_M16_per_finger l_M16 nf_M16 w_M13_per_finger l_M13 nf_M13 w_M12_per_finger l_M12 nf_M12 w_M31_per_finger l_M31 nf_M31 w_M33_per_finger l_M33 nf_M33 w_M37_per_finger l_M37 nf_M37 w_M38_per_finger l_M38 nf_M38 w_M32_per_finger l_M32 nf_M32 w_M34_per_finger l_M34 nf_M34 w_M35_per_finger l_M35 nf_M35 w_M36_per_finger l_M36 nf_M36 w_M23_per_finger l_M23 nf_M23 w_M24_per_finger l_M24 nf_M24 w_M27_per_finger l_M27 nf_M27 w_M28_per_finger l_M28 nf_M28 w_M21_per_finger l_M21 nf_M21 w_M22_per_finger l_M22 nf_M22 w_M25_per_finger l_M25 nf_M25 w_M26_per_finger l_M26 nf_M26 w_M2_per_finger l_M2 nf_M2 w_M1_per_finger l_M1 nf_M1
include "/data/PDK/pdk_installed/tsmc180bcd_g2/pdk/pdk_1p6m/tsmc18/../models/spectre/c018bcd_gen2_v1d6_usage.scs" section=pre_simu
include "/data/PDK/pdk_installed/tsmc180bcd_g2/pdk/pdk_1p6m/tsmc18/../models/spectre/c018bcd_gen2_v1d6_usage.scs" section=tt_lib
// Buck/driver_s2/schematic
subckt driver_s2 IN OUT VDD VSS
    M45 (OUT net028 VDD VDD) pch_5_mac l=l_M45 w=w_M45_per_finger*nf_M45 multi=1 nf=nf_M45 sigma=1 mismatchflag=1
    M46 (net028 net026 VDD VDD) pch_5_mac l=l_M46 w=w_M46_per_finger*nf_M46 multi=1 nf=nf_M46 sigma=1 mismatchflag=1
    M47 (net026 net024 VDD VDD) pch_5_mac l=l_M47 w=w_M47_per_finger*nf_M47 multi=1 nf=nf_M47 sigma=1 mismatchflag=1
    M48 (net024 IN VDD VDD) pch_5_mac l=l_M48 w=w_M48_per_finger*nf_M48 multi=1 nf=nf_M48 sigma=1 mismatchflag=1
    M41 (OUT net028 VSS VSS) nch_5_mac l=l_M41 w=w_M41_per_finger*nf_M41 multi=1 nf=nf_M41 sigma=1 mismatchflag=1
    M42 (net028 net026 VSS VSS) nch_5_mac l=l_M42 w=w_M42_per_finger*nf_M42 multi=1 nf=nf_M42 sigma=1 mismatchflag=1
    M43 (net026 net024 VSS VSS) nch_5_mac l=l_M43 w=w_M43_per_finger*nf_M43 multi=1 nf=nf_M43 sigma=1 mismatchflag=1
    M44 (net024 IN VSS VSS) nch_5_mac l=l_M44 w=w_M44_per_finger*nf_M44 multi=1 nf=nf_M44 sigma=1 mismatchflag=1
ends driver_s2
// tsmc18_stdc_5v/DEL4/schematic
subckt DEL4 I Z VDD VSS
    MI4\-M_u3 (net33 net45 VDD VDD) pch_5 l=1.09u w=420.0n m=1 nf=1
    MI8\-M_u3 (net11 net33 VDD VDD) pch_5 l=1.09u w=420.0n m=1 nf=1
    MI3\-M_u3 (Z net9 VDD VDD) pch_5 l=500n w=1.62u m=1 nf=1
    MI7\-M_u3 (net9 net11 VDD VDD) pch_5 l=1.09u w=420.0n m=1 nf=1
    MI6\-M_u3 (net5 I VDD VDD) pch_5 l=500n w=1.62u m=1 nf=1
    MI5\-M_u3 (net45 net5 VDD VDD) pch_5 l=1.09u w=420.0n m=1 nf=1
    MI5\-M_u2 (net45 net5 VSS VSS) nch_5 l=1.09u w=1.26u m=1 nf=1
    MI8\-M_u2 (net11 net33 VSS VSS) nch_5 l=1.09u w=420.0n m=1 nf=1
    MI3\-M_u2 (Z net9 VSS VSS) nch_5 l=600n w=1.26u m=1 nf=1
    MI4\-M_u2 (net33 net45 VSS VSS) nch_5 l=1.09u w=420.0n m=1 nf=1
    MI6\-M_u2 (net5 I VSS VSS) nch_5 l=600n w=1.26u m=1 nf=1
    MI7\-M_u2 (net9 net11 VSS VSS) nch_5 l=1.09u w=1.26u m=1 nf=1
ends DEL4
// tsmc18_stdc_5v/INVD0/schematic
subckt INVD0 I ZN VDD VSS
    MU1\-M_u2 (ZN I VSS VSS) nch_5 l=600n w=630.0n m=1 nf=1
    MU1\-M_u3 (ZN I VDD VDD) pch_5 l=500n w=810.0n m=1 nf=1
ends INVD0
// tsmc18_stdc_5v/BUFFD0/schematic
subckt BUFFD0 I Z VDD VSS
    MI2\-M_u3 (net5 I VDD VDD) pch_5 l=500n w=810.0n m=1 nf=1
    MI1\-M_u3 (Z net5 VDD VDD) pch_5 l=500n w=810.0n m=1 nf=1
    MI2\-M_u2 (net5 I VSS VSS) nch_5 l=600n w=630.0n m=1 nf=1
    MI1\-M_u2 (Z net5 VSS VSS) nch_5 l=600n w=630.0n m=1 nf=1
ends BUFFD0
// Buck/deadtime/schematic
subckt deadtime IN OUT1 OUT2 VDD VSS
    M15 (net09 net28 net24 net24) pch_5_mac l=l_M15 w=w_M15_per_finger*nf_M15 multi=1 nf=nf_M15 sigma=1 mismatchflag=1
    M14 (net24 IN VDD VDD) pch_5_mac l=l_M14 w=w_M14_per_finger*nf_M14 multi=1 nf=nf_M14 sigma=1 mismatchflag=1
    M11 (net010 IN VDD VDD) pch_5_mac l=l_M11 w=w_M11_per_finger*nf_M11 multi=1 nf=nf_M11 sigma=1 mismatchflag=1
    I9 (net36 net34 VDD VSS) DEL4
    I47 (IN net36 VDD VSS) DEL4
    I8 (net35 net28 VDD VSS) DEL4
    I50 (IN net35 VDD VSS) DEL4
    I0 (net010 OUT1 VDD VSS) INVD0
    I1 (net09 OUT2 VDD VSS) BUFFD0
    M16 (net09 IN VSS VSS) nch_5_mac l=l_M16 w=w_M16_per_finger*nf_M16 multi=1 nf=nf_M16 sigma=1 mismatchflag=1
    M13 (net21 IN VSS VSS) nch_5_mac l=l_M13 w=w_M13_per_finger*nf_M13 multi=1 nf=nf_M13 sigma=1 mismatchflag=1
    M12 (net010 net34 net21 net21) nch_5_mac l=l_M12 w=w_M12_per_finger*nf_M12 multi=1 nf=nf_M12 sigma=1 mismatchflag=1
ends deadtime
// Buck/driver_s1/schematic
subckt driver_s1 IN OUT VDD VSS
    M31 (OUT net16 VDD VDD) pch_5_mac l=l_M31 w=w_M31_per_finger*nf_M31 multi=1 nf=nf_M31 sigma=1 mismatchflag=1
    M33 (net16 net14 VDD VDD) pch_5_mac l=l_M33 w=w_M33_per_finger*nf_M33 multi=1 nf=nf_M33 sigma=1 mismatchflag=1
    M37 (net14 net13 VDD VDD) pch_5_mac l=l_M37 w=w_M37_per_finger*nf_M37 multi=1 nf=nf_M37 sigma=1 mismatchflag=1
    M38 (net13 IN VDD VDD) pch_5_mac l=l_M38 w=w_M38_per_finger*nf_M38 multi=1 nf=nf_M38 sigma=1 mismatchflag=1
    M32 (OUT net16 VSS VSS) nch_5_mac l=l_M32 w=w_M32_per_finger*nf_M32 multi=1 nf=nf_M32 sigma=1 mismatchflag=1
    M34 (net16 net14 VSS VSS) nch_5_mac l=l_M34 w=w_M34_per_finger*nf_M34 multi=1 nf=nf_M34 sigma=1 mismatchflag=1
    M35 (net14 net13 VSS VSS) nch_5_mac l=l_M35 w=w_M35_per_finger*nf_M35 multi=1 nf=nf_M35 sigma=1 mismatchflag=1
    M36 (net13 IN VSS VSS) nch_5_mac l=l_M36 w=w_M36_per_finger*nf_M36 multi=1 nf=nf_M36 sigma=1 mismatchflag=1
ends driver_s1
// tsmc18_stdc_5v/INVD1/schematic
subckt INVD1 I ZN VDD VSS
    MU1\-M_u2 (ZN I VSS VSS) nch_5 l=600n w=1.26u m=1 nf=1
    MU1\-M_u3 (ZN I VDD VDD) pch_5 l=500n w=1.62u m=1 nf=1
ends INVD1
// Buck/level_shifter/schematic
subckt level_shifter IN OUT VDDH VDDL VSSH VSSL
    M23 (VSM VS VDDH VDDH) pch_5_mac l=l_M23 w=w_M23_per_finger*nf_M23 multi=1 nf=nf_M23 sigma=1 mismatchflag=1
    M24 (VS VSM VDDH VDDH) pch_5_mac l=l_M24 w=w_M24_per_finger*nf_M24 multi=1 nf=nf_M24 sigma=1 mismatchflag=1
    M27 (VD VSSH VS VS) pch_5_mac l=l_M27 w=w_M27_per_finger*nf_M27 multi=1 nf=nf_M27 sigma=1 mismatchflag=1
    M28 (VDM VSSH VSM VSM) pch_5_mac l=l_M28 w=w_M28_per_finger*nf_M28 multi=1 nf=nf_M28 sigma=1 mismatchflag=1
    I3 (VS OUT VDDH VSSH) INVD1
    I2 (IN net11 VDDL VSSL) INVD1
    I1 (net11 net12 VDDL VSSL) INVD1
    I0 (IN net13 VDDL VSSL) INVD1
    M21 (VD net12 VSSL VSSL) nch_5_mac l=l_M21 w=w_M21_per_finger*nf_M21 multi=1 nf=nf_M21 sigma=1 mismatchflag=1
    M22 (VDM net13 VSSL VSSL) nch_5_mac l=l_M22 w=w_M22_per_finger*nf_M22 multi=1 nf=nf_M22 sigma=1 mismatchflag=1
    M25 (VS VSSH VSSH VSSH) nch_5_mac l=l_M25 w=w_M25_per_finger*nf_M25 multi=1 nf=nf_M25 sigma=1 mismatchflag=1
    M26 (VSM VSSH VSSH VSSH) nch_5_mac l=l_M26 w=w_M26_per_finger*nf_M26 multi=1 nf=nf_M26 sigma=1 mismatchflag=1
ends level_shifter
// Buck/Buck_Core/schematic
subckt Buck_Core GND VC VIN VOUT
    I1 (VCL VGL VIN GND) driver_s2
    M2 (SW VGL GND GND) nch_5_mac l=l_M2 w=w_M2_per_finger*nf_M2 multi=1 nf=nf_M2 sigma=1 mismatchflag=1
    M1 (VIN VGH SW SW) nch_5_mac l=l_M1 w=w_M1_per_finger*nf_M1 multi=1 nf=nf_M1 sigma=1 mismatchflag=1
    I3 (VC VCH VCL VIN GND) deadtime
    C1 (VBST SW) capacitor c=1n
    L0 (SW VOUT) inductor l=240.00n r=25m
    I0 (VCH_LS VGH VBST SW) driver_s1
    I10 (VCH VCH_LS VBST VIN SW GND) level_shifter
    D2 (VIN VBST GND) sbd_dio_ga_12_3t dti=0 multi=20
ends Buck_Core
// Buck/tb/schematic
I11 (GND VC VIN VOUT) Buck_Core
C0 (VOUT net010) capacitor c=22u
R0 (net010 GND) resistor r=4m
V0 (VIN 0) vsource dc=3.3 type=dc
V1 (GND 0) vsource dc=0 type=dc
V2 (VC 0) vsource dc=0 type=pulse val0=0 val1=3.3 period=250.00n rise=1n fall=1n width=75n
I6 (VOUT GND) isource dc=ILOAD type=dc
simulatorOptions options temp=27
tran tran stop=60u errpreset=conservative cmin=10a
save V0:p
