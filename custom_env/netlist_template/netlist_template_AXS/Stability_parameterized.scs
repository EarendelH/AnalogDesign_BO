// Design: LDO_AXS/tb_Stability
simulator lang=spectre
global 0
parameters DVDD=1.2 ESR=3 V0=0 V1=0 V2=0 V3=0 r_load=240 VDDI=1.65 VREF=0.5 POC_VDDI=1.65 EN=1.65 w_M115_per_finger l_M115 nf_M115 w_M114_per_finger l_M114 nf_M114 w_M113_per_finger l_M113 nf_M113 w_M112_per_finger l_M112 nf_M112 w_M111_per_finger l_M111 nf_M111 w_M110_per_finger l_M110 nf_M110 w_M103_per_finger l_M103 nf_M103 w_M104_per_finger l_M104 nf_M104 w_M105_per_finger l_M105 nf_M105 w_M106_per_finger l_M106 nf_M106 w_M107_per_finger l_M107 nf_M107 w_M108_per_finger l_M108 nf_M108 w_M109_per_finger l_M109 nf_M109 w_M116_per_finger l_M116 nf_M116 w_M101_per_finger l_M101 nf_M101 w_M102_per_finger l_M102 nf_M102 w_M201_per_finger l_M201 nf_M201 w_M202_per_finger l_M202 nf_M202 w_M203_per_finger l_M203 nf_M203 w_M204_per_finger l_M204 nf_M204 w_M205_per_finger l_M205 nf_M205 w_M206_per_finger l_M206 nf_M206 w_M50_per_finger l_M50 nf_M50 w_M49_per_finger l_M49 nf_M49 w_M36_per_finger l_M36 nf_M36 w_M35_per_finger l_M35 nf_M35 w_M23_per_finger l_M23 nf_M23 w_M19_per_finger l_M19 nf_M19 w_M47_per_finger l_M47 nf_M47 w_M43_per_finger l_M43 nf_M43 w_M42_per_finger l_M42 nf_M42 w_M39_per_finger l_M39 nf_M39 w_M25_per_finger l_M25 nf_M25 w_M18_per_finger l_M18 nf_M18 w_M20_per_finger l_M20 nf_M20 w_M26_per_finger l_M26 nf_M26 w_M24_per_finger l_M24 nf_M24 w_M22_per_finger l_M22 nf_M22 w_M21_per_finger l_M21 nf_M21 w_M28_per_finger l_M28 nf_M28 w_M51_per_finger l_M51 nf_M51 w_M46_per_finger l_M46 nf_M46 w_M44_per_finger l_M44 nf_M44 w_M41_per_finger l_M41 nf_M41 w_M40_per_finger l_M40 nf_M40 w_M34_per_finger l_M34 nf_M34 w_M10_per_finger l_M10 nf_M10 w_M3_per_finger l_M3 nf_M3 w_M2_per_finger l_M2 nf_M2 w_M11_per_finger l_M11 nf_M11 w_M5_per_finger l_M5 nf_M5 w_M9_per_finger l_M9 nf_M9 w_M1_per_finger l_M1 nf_M1 w_M16_per_finger l_M16 nf_M16 w_M15_per_finger l_M15 nf_M15 w_M7_per_finger l_M7 nf_M7 w_M6_per_finger l_M6 nf_M6 w_M0_per_finger l_M0 nf_M0 w_M4_per_finger l_M4 nf_M4
include "/home/wuhan/Downloads/spectre/HLMC_55HV_MV8V_V1P12_CORNER.LIB" section=FF
include "/home/wuhan/Downloads/spectre/HLMC_55HV_MV8V_V1P12_CORNER.LIB" section=DIO_ALL_TT
include "/home/wuhan/Downloads/spectre/HLMC_55HV_MV8V_V1P12_CORNER.LIB" section=BJT_ALL_TT
include "/home/wuhan/Downloads/spectre/HLMC_55HV_MV8V_V1P12_CORNER.LIB" section=RES_ALL_TT
include "/home/wuhan/Downloads/spectre/HLMC_55HV_MV8V_V1P12_CORNER.LIB" section=VAR_ALL_TT
include "/home/wuhan/Downloads/spectre/HLMC_55HV_MV8V_V1P12_CORNER.LIB" section=MOM_ALL_TT

// AXS3804_ALF_LDO_DVDD_20mA/nmos_bias/schematic
subckt nmos_bias B D G S
    M115 (net6 G net10 B) n8ud33io w=(4u) l=2u nf=1 multi=(1) mismatch=1 global_flag=1
    M114 (net9 G net6 B) n8ud33io w=(4u) l=2u nf=1 multi=(1) mismatch=1 global_flag=1
    M113 (net2 G net9 B) n8ud33io w=(4u) l=2u nf=1 multi=(1) mismatch=1 global_flag=1
    M112 (net8 G net2 B) n8ud33io w=(4u) l=2u nf=1 multi=(1) mismatch=1 global_flag=1
    M111 (net4 G net8 B) n8ud33io w=(4u) l=2u nf=1 multi=(1) mismatch=1 global_flag=1
    M110 (net3 G net4 B) n8ud33io w=(4u) l=2u nf=1 multi=(1) mismatch=1 global_flag=1
    M103 (net20 G net15 B) n8ud33io w=(4u) l=2u nf=1 multi=(1) mismatch=1 global_flag=1
    M104 (net15 G net16 B) n8ud33io w=(4u) l=2u nf=1 multi=(1) mismatch=1 global_flag=1
    M105 (net16 G net14 B) n8ud33io w=(4u) l=2u nf=1 multi=(1) mismatch=1 global_flag=1
    M106 (net14 G net1 B) n8ud33io w=(4u) l=2u nf=1 multi=(1) mismatch=1 global_flag=1
    M107 (net1 G net5 B) n8ud33io w=(4u) l=2u nf=1 multi=(1) mismatch=1 global_flag=1
    M108 (net5 G net7 B) n8ud33io w=(4u) l=2u nf=1 multi=(1) mismatch=1 global_flag=1
    M109 (net7 G net3 B) n8ud33io w=(4u) l=2u nf=1 multi=(1) mismatch=1 global_flag=1
    M116 (net10 G S B) n8ud33io w=(4u) l=2u nf=1 multi=(1) mismatch=1 global_flag=1
    M101 (D G net19 B) n8ud33io w=(4u) l=2u nf=1 multi=(1) mismatch=1 global_flag=1
    M102 (net19 G net20 B) n8ud33io w=(4u) l=2u nf=1 multi=(1) mismatch=1 global_flag=1
ends nmos_bias

// HLMC55HV_ANALOG_BASIC_LOGIC_AI/inv_x1_3p3v/schematic
subckt inv_x1_3p3v AVDD AVSS IN OUT
    M0 (OUT IN AVDD AVDD) p8ud33io w=(2.2u) l=700n nf=1 multi=(1) global_flag=0
    M1 (OUT IN AVSS AVSS) n8ud33io w=(1u) l=800n nf=1 multi=(1) global_flag=0
ends inv_x1_3p3v

// HLMC55HV_ANALOG_BASIC_LOGIC_AI/tg_x1_3p3v/schematic
subckt tg_x1_3p3v A AVDD AVSS B EN
    M0 (A EN_N B AVDD) p8ud33io w=(2.2u) l=700n nf=1 multi=(1) global_flag=0
    I0 (AVDD AVSS EN EN_N) inv_x1_3p3v
    M1 (A EN B AVSS) n8ud33io w=(1u) l=800n nf=1 multi=(1) global_flag=0
ends tg_x1_3p3v

// hlmc55hv/res_pposab/schematic
subckt res_pposab_pcell_0 B MINUS PLUS
parameters segL=8u segW=2u res_mismatch=1 flag_cap=1
    R3 (n3 MINUS B) res_pposab l=segL w=segW res_mismatch=res_mismatch flag_cap=flag_cap
    R2 (n2 n3 B) res_pposab l=segL w=segW res_mismatch=res_mismatch flag_cap=flag_cap
    R1 (n1 n2 B) res_pposab l=segL w=segW res_mismatch=res_mismatch flag_cap=flag_cap
    R0 (PLUS n1 B) res_pposab l=segL w=segW res_mismatch=res_mismatch flag_cap=flag_cap
ends res_pposab_pcell_0

// AXS3804_ALF_LDO_DVDD_20mA/RES_FB/schematic
subckt RES_FB A AVSS B
    R59 (AVSS net9 net8) res_pposab_pcell_0 m=1 segL=5u segW=1u res_mismatch=1 flag_cap=1
    R58 (AVSS B net12) res_pposab_pcell_0 m=1 segL=5u segW=1u res_mismatch=1 flag_cap=1
    R56 (AVSS net11 net10) res_pposab_pcell_0 m=1 segL=5u segW=1u res_mismatch=1 flag_cap=1
    R55 (AVSS net12 net11) res_pposab_pcell_0 m=1 segL=5u segW=1u res_mismatch=1 flag_cap=1
    R54 (AVSS net10 net9) res_pposab_pcell_0 m=1 segL=5u segW=1u res_mismatch=1 flag_cap=1
    R53 (AVSS net7 net8) res_pposab_pcell_0 m=1 segL=5u segW=1u res_mismatch=1 flag_cap=1
    R52 (AVSS net3 net4) res_pposab_pcell_0 m=1 segL=5u segW=1u res_mismatch=1 flag_cap=1
    R50 (AVSS net5 net6) res_pposab_pcell_0 m=1 segL=5u segW=1u res_mismatch=1 flag_cap=1
    R49 (AVSS net4 net5) res_pposab_pcell_0 m=1 segL=5u segW=1u res_mismatch=1 flag_cap=1
    R48 (AVSS net6 net7) res_pposab_pcell_0 m=1 segL=5u segW=1u res_mismatch=1 flag_cap=1
    R47 (AVSS net23 net22) res_pposab_pcell_0 m=1 segL=5u segW=1u res_mismatch=1 flag_cap=1
    R46 (AVSS net3 net2) res_pposab_pcell_0 m=1 segL=5u segW=1u res_mismatch=1 flag_cap=1
    R44 (AVSS net1 net24) res_pposab_pcell_0 m=1 segL=5u segW=1u res_mismatch=1 flag_cap=1
    R43 (AVSS net2 net1) res_pposab_pcell_0 m=1 segL=5u segW=1u res_mismatch=1 flag_cap=1
    R42 (AVSS net24 net23) res_pposab_pcell_0 m=1 segL=5u segW=1u res_mismatch=1 flag_cap=1
    R41 (AVSS net18 net22) res_pposab_pcell_0 m=1 segL=5u segW=1u res_mismatch=1 flag_cap=1
    R40 (AVSS net17 net21) res_pposab_pcell_0 m=1 segL=5u segW=1u res_mismatch=1 flag_cap=1
    R38 (AVSS net20 net19) res_pposab_pcell_0 m=1 segL=5u segW=1u res_mismatch=1 flag_cap=1
    R37 (AVSS net21 net20) res_pposab_pcell_0 m=1 segL=5u segW=1u res_mismatch=1 flag_cap=1
    R36 (AVSS net19 net18) res_pposab_pcell_0 m=1 segL=5u segW=1u res_mismatch=1 flag_cap=1
    R35 (AVSS net13 A) res_pposab_pcell_0 m=1 segL=5u segW=1u res_mismatch=1 flag_cap=1
    R34 (AVSS net17 net16) res_pposab_pcell_0 m=1 segL=5u segW=1u res_mismatch=1 flag_cap=1
    R32 (AVSS net15 net14) res_pposab_pcell_0 m=1 segL=5u segW=1u res_mismatch=1 flag_cap=1
    R31 (AVSS net16 net15) res_pposab_pcell_0 m=1 segL=5u segW=1u res_mismatch=1 flag_cap=1
    R30 (AVSS net14 net13) res_pposab_pcell_0 m=1 segL=5u segW=1u res_mismatch=1 flag_cap=1
ends RES_FB

// AXS3804_ALF_LDO_DVDD_20mA/RES_ADJ/schematic
subckt RES_ADJ A AVSS B RES_ADJ\<3\> RES_ADJ\<2\> RES_ADJ\<1\> RES_ADJ\<0\>
    R59 (AVSS net9 net8) res_pposab_pcell_0 m=1 segL=5u segW=1u res_mismatch=1 flag_cap=1
    R58 (AVSS net26 net12) res_pposab_pcell_0 m=1 segL=5u segW=1u res_mismatch=1 flag_cap=1
    R56 (AVSS net11 net10) res_pposab_pcell_0 m=1 segL=5u segW=1u res_mismatch=1 flag_cap=1
    R55 (AVSS net12 net11) res_pposab_pcell_0 m=1 segL=5u segW=1u res_mismatch=1 flag_cap=1
    R54 (AVSS net10 net9) res_pposab_pcell_0 m=1 segL=5u segW=1u res_mismatch=1 flag_cap=1
    R53 (AVSS net7 net8) res_pposab_pcell_0 m=1 segL=5u segW=1u res_mismatch=1 flag_cap=1
    R52 (AVSS net3 net4) res_pposab_pcell_0 m=1 segL=5u segW=1u res_mismatch=1 flag_cap=1
    R50 (AVSS net5 net18) res_pposab_pcell_0 m=1 segL=5u segW=1u res_mismatch=1 flag_cap=1
    R49 (AVSS net4 net5) res_pposab_pcell_0 m=1 segL=5u segW=1u res_mismatch=1 flag_cap=1
    R48 (AVSS net18 net7) res_pposab_pcell_0 m=1 segL=5u segW=1u res_mismatch=1 flag_cap=1
    R47 (AVSS net6 V\<0\>) res_pposab_pcell_0 m=1 segL=5u segW=1u res_mismatch=1 flag_cap=1
    R46 (AVSS net3 net2) res_pposab_pcell_0 m=1 segL=5u segW=1u res_mismatch=1 flag_cap=1
    R78 (AVSS V\<4\> A) res_pposab_pcell_0 m=1 segL=5u segW=1u res_mismatch=1 flag_cap=1
    R44 (AVSS net1 net15) res_pposab_pcell_0 m=1 segL=5u segW=1u res_mismatch=1 flag_cap=1
    R43 (AVSS net2 net1) res_pposab_pcell_0 m=1 segL=5u segW=1u res_mismatch=1 flag_cap=1
    R42 (AVSS net15 net6) res_pposab_pcell_0 m=1 segL=5u segW=1u res_mismatch=1 flag_cap=1
    R41 (AVSS V\<1\> V\<0\>) res_pposab_pcell_0 m=1 segL=5u segW=1u res_mismatch=1 flag_cap=1
    R40 (AVSS net17 net21) res_pposab_pcell_0 m=1 segL=5u segW=1u res_mismatch=1 flag_cap=1
    R38 (AVSS V\<2\> net19) res_pposab_pcell_0 m=1 segL=5u segW=1u res_mismatch=1 flag_cap=1
    R37 (AVSS net21 V\<2\>) res_pposab_pcell_0 m=1 segL=5u segW=1u res_mismatch=1 flag_cap=1
    R36 (AVSS net19 V\<1\>) res_pposab_pcell_0 m=1 segL=5u segW=1u res_mismatch=1 flag_cap=1
    R35 (AVSS net13 net39) res_pposab_pcell_0 m=1 segL=5u segW=1u res_mismatch=1 flag_cap=1
    R34 (AVSS net17 net16) res_pposab_pcell_0 m=1 segL=5u segW=1u res_mismatch=1 flag_cap=1
    R32 (AVSS V\<3\> net14) res_pposab_pcell_0 m=1 segL=5u segW=1u res_mismatch=1 flag_cap=1
    R31 (AVSS net16 V\<3\>) res_pposab_pcell_0 m=1 segL=5u segW=1u res_mismatch=1 flag_cap=1
    R30 (AVSS net14 net13) res_pposab_pcell_0 m=1 segL=5u segW=1u res_mismatch=1 flag_cap=1
    R74 (AVSS net37 net39) res_pposab_pcell_0 m=1 segL=5u segW=1u res_mismatch=1 flag_cap=1
    R70 (AVSS V\<4\> net35) res_pposab_pcell_0 m=1 segL=5u segW=1u res_mismatch=1 flag_cap=1
    R69 (AVSS net34 net30) res_pposab_pcell_0 m=1 segL=5u segW=1u res_mismatch=1 flag_cap=1
    R73 (AVSS net36 net37) res_pposab_pcell_0 m=1 segL=5u segW=1u res_mismatch=1 flag_cap=1
    R68 (AVSS net33 net34) res_pposab_pcell_0 m=1 segL=5u segW=1u res_mismatch=1 flag_cap=1
    R67 (AVSS net32 net33) res_pposab_pcell_0 m=1 segL=5u segW=1u res_mismatch=1 flag_cap=1
    R66 (AVSS net31 net32) res_pposab_pcell_0 m=1 segL=5u segW=1u res_mismatch=1 flag_cap=1
    R65 (AVSS B net31) res_pposab_pcell_0 m=1 segL=5u segW=1u res_mismatch=1 flag_cap=1
    R64 (AVSS net29 net30) res_pposab_pcell_0 m=1 segL=5u segW=1u res_mismatch=1 flag_cap=1
    R72 (AVSS net22 net36) res_pposab_pcell_0 m=1 segL=5u segW=1u res_mismatch=1 flag_cap=1
    R63 (AVSS net28 net29) res_pposab_pcell_0 m=1 segL=5u segW=1u res_mismatch=1 flag_cap=1
    R62 (AVSS net27 net28) res_pposab_pcell_0 m=1 segL=5u segW=1u res_mismatch=1 flag_cap=1
    R61 (AVSS net25 net27) res_pposab_pcell_0 m=1 segL=5u segW=1u res_mismatch=1 flag_cap=1
    R60 (AVSS net26 net25) res_pposab_pcell_0 m=1 segL=5u segW=1u res_mismatch=1 flag_cap=1
    R71 (AVSS net35 net22) res_pposab_pcell_0 m=1 segL=5u segW=1u res_mismatch=1 flag_cap=1
    M3 (V\<0\> RES_ADJ\<0\> V\<1\> V\<4\>) p8ud33io w=(10u) l=700n nf=1 multi=(10) mismatch=1 global_flag=1
    M2 (V\<1\> RES_ADJ\<1\> V\<2\> V\<4\>) p8ud33io w=(10u) l=700n nf=1 multi=(10) mismatch=1 global_flag=1
    M1 (V\<2\> RES_ADJ\<2\> V\<3\> V\<4\>) p8ud33io w=(10u) l=700n nf=1 multi=(10) mismatch=1 global_flag=1
    M0 (V\<3\> RES_ADJ\<3\> V\<4\> V\<4\>) p8ud33io w=(10u) l=700n nf=1 multi=(10) mismatch=1 global_flag=1
    M8 (V\<4\> AVSS V\<4\> V\<4\>) p8ud33io w=(10u) l=4u nf=1 multi=(15) global_flag=0
ends RES_ADJ

// hlmc55hv/res_pposab/schematic
subckt res_pposab_pcell_1 B MINUS PLUS
parameters segL=8u segW=2u res_mismatch=1 flag_cap=1
    R1 (PLUS MINUS B) res_pposab l=segL w=segW res_mismatch=res_mismatch flag_cap=flag_cap
    R0 (PLUS MINUS B) res_pposab l=segL w=segW res_mismatch=res_mismatch flag_cap=flag_cap
ends res_pposab_pcell_1

// hlmc55hv/res_pposab/schematic
subckt res_pposab_pcell_2 B MINUS PLUS
parameters segL=8u segW=2u res_mismatch=1 flag_cap=1
    R31 (n31 MINUS B) res_pposab l=segL w=segW res_mismatch=res_mismatch flag_cap=flag_cap
    R30 (n30 n31 B) res_pposab l=segL w=segW res_mismatch=res_mismatch flag_cap=flag_cap
    R29 (n29 n30 B) res_pposab l=segL w=segW res_mismatch=res_mismatch flag_cap=flag_cap
    R28 (n28 n29 B) res_pposab l=segL w=segW res_mismatch=res_mismatch flag_cap=flag_cap
    R27 (n27 n28 B) res_pposab l=segL w=segW res_mismatch=res_mismatch flag_cap=flag_cap
    R26 (n26 n27 B) res_pposab l=segL w=segW res_mismatch=res_mismatch flag_cap=flag_cap
    R25 (n25 n26 B) res_pposab l=segL w=segW res_mismatch=res_mismatch flag_cap=flag_cap
    R24 (n24 n25 B) res_pposab l=segL w=segW res_mismatch=res_mismatch flag_cap=flag_cap
    R23 (n23 n24 B) res_pposab l=segL w=segW res_mismatch=res_mismatch flag_cap=flag_cap
    R22 (n22 n23 B) res_pposab l=segL w=segW res_mismatch=res_mismatch flag_cap=flag_cap
    R21 (n21 n22 B) res_pposab l=segL w=segW res_mismatch=res_mismatch flag_cap=flag_cap
    R20 (n20 n21 B) res_pposab l=segL w=segW res_mismatch=res_mismatch flag_cap=flag_cap
    R19 (n19 n20 B) res_pposab l=segL w=segW res_mismatch=res_mismatch flag_cap=flag_cap
    R18 (n18 n19 B) res_pposab l=segL w=segW res_mismatch=res_mismatch flag_cap=flag_cap
    R17 (n17 n18 B) res_pposab l=segL w=segW res_mismatch=res_mismatch flag_cap=flag_cap
    R16 (n16 n17 B) res_pposab l=segL w=segW res_mismatch=res_mismatch flag_cap=flag_cap
    R15 (n15 n16 B) res_pposab l=segL w=segW res_mismatch=res_mismatch flag_cap=flag_cap
    R14 (n14 n15 B) res_pposab l=segL w=segW res_mismatch=res_mismatch flag_cap=flag_cap
    R13 (n13 n14 B) res_pposab l=segL w=segW res_mismatch=res_mismatch flag_cap=flag_cap
    R12 (n12 n13 B) res_pposab l=segL w=segW res_mismatch=res_mismatch flag_cap=flag_cap
    R11 (n11 n12 B) res_pposab l=segL w=segW res_mismatch=res_mismatch flag_cap=flag_cap
    R10 (n10 n11 B) res_pposab l=segL w=segW res_mismatch=res_mismatch flag_cap=flag_cap
    R9 (n9 n10 B) res_pposab l=segL w=segW res_mismatch=res_mismatch flag_cap=flag_cap
    R8 (n8 n9 B) res_pposab l=segL w=segW res_mismatch=res_mismatch flag_cap=flag_cap
    R7 (n7 n8 B) res_pposab l=segL w=segW res_mismatch=res_mismatch flag_cap=flag_cap
    R6 (n6 n7 B) res_pposab l=segL w=segW res_mismatch=res_mismatch flag_cap=flag_cap
    R5 (n5 n6 B) res_pposab l=segL w=segW res_mismatch=res_mismatch flag_cap=flag_cap
    R4 (n4 n5 B) res_pposab l=segL w=segW res_mismatch=res_mismatch flag_cap=flag_cap
    R3 (n3 n4 B) res_pposab l=segL w=segW res_mismatch=res_mismatch flag_cap=flag_cap
    R2 (n2 n3 B) res_pposab l=segL w=segW res_mismatch=res_mismatch flag_cap=flag_cap
    R1 (n1 n2 B) res_pposab l=segL w=segW res_mismatch=res_mismatch flag_cap=flag_cap
    R0 (PLUS n1 B) res_pposab l=segL w=segW res_mismatch=res_mismatch flag_cap=flag_cap
ends res_pposab_pcell_2

// hlmc55hv/res_pposab/schematic
subckt res_pposab_pcell_3 B MINUS PLUS
parameters segL=8u segW=2u res_mismatch=1 flag_cap=1
    R39 (n39 MINUS B) res_pposab l=segL w=segW res_mismatch=res_mismatch flag_cap=flag_cap
    R38 (n38 n39 B) res_pposab l=segL w=segW res_mismatch=res_mismatch flag_cap=flag_cap
    R37 (n37 n38 B) res_pposab l=segL w=segW res_mismatch=res_mismatch flag_cap=flag_cap
    R36 (n36 n37 B) res_pposab l=segL w=segW res_mismatch=res_mismatch flag_cap=flag_cap
    R35 (n35 n36 B) res_pposab l=segL w=segW res_mismatch=res_mismatch flag_cap=flag_cap
    R34 (n34 n35 B) res_pposab l=segL w=segW res_mismatch=res_mismatch flag_cap=flag_cap
    R33 (n33 n34 B) res_pposab l=segL w=segW res_mismatch=res_mismatch flag_cap=flag_cap
    R32 (n32 n33 B) res_pposab l=segL w=segW res_mismatch=res_mismatch flag_cap=flag_cap
    R31 (n31 n32 B) res_pposab l=segL w=segW res_mismatch=res_mismatch flag_cap=flag_cap
    R30 (n30 n31 B) res_pposab l=segL w=segW res_mismatch=res_mismatch flag_cap=flag_cap
    R29 (n29 n30 B) res_pposab l=segL w=segW res_mismatch=res_mismatch flag_cap=flag_cap
    R28 (n28 n29 B) res_pposab l=segL w=segW res_mismatch=res_mismatch flag_cap=flag_cap
    R27 (n27 n28 B) res_pposab l=segL w=segW res_mismatch=res_mismatch flag_cap=flag_cap
    R26 (n26 n27 B) res_pposab l=segL w=segW res_mismatch=res_mismatch flag_cap=flag_cap
    R25 (n25 n26 B) res_pposab l=segL w=segW res_mismatch=res_mismatch flag_cap=flag_cap
    R24 (n24 n25 B) res_pposab l=segL w=segW res_mismatch=res_mismatch flag_cap=flag_cap
    R23 (n23 n24 B) res_pposab l=segL w=segW res_mismatch=res_mismatch flag_cap=flag_cap
    R22 (n22 n23 B) res_pposab l=segL w=segW res_mismatch=res_mismatch flag_cap=flag_cap
    R21 (n21 n22 B) res_pposab l=segL w=segW res_mismatch=res_mismatch flag_cap=flag_cap
    R20 (n20 n21 B) res_pposab l=segL w=segW res_mismatch=res_mismatch flag_cap=flag_cap
    R19 (n19 n20 B) res_pposab l=segL w=segW res_mismatch=res_mismatch flag_cap=flag_cap
    R18 (n18 n19 B) res_pposab l=segL w=segW res_mismatch=res_mismatch flag_cap=flag_cap
    R17 (n17 n18 B) res_pposab l=segL w=segW res_mismatch=res_mismatch flag_cap=flag_cap
    R16 (n16 n17 B) res_pposab l=segL w=segW res_mismatch=res_mismatch flag_cap=flag_cap
    R15 (n15 n16 B) res_pposab l=segL w=segW res_mismatch=res_mismatch flag_cap=flag_cap
    R14 (n14 n15 B) res_pposab l=segL w=segW res_mismatch=res_mismatch flag_cap=flag_cap
    R13 (n13 n14 B) res_pposab l=segL w=segW res_mismatch=res_mismatch flag_cap=flag_cap
    R12 (n12 n13 B) res_pposab l=segL w=segW res_mismatch=res_mismatch flag_cap=flag_cap
    R11 (n11 n12 B) res_pposab l=segL w=segW res_mismatch=res_mismatch flag_cap=flag_cap
    R10 (n10 n11 B) res_pposab l=segL w=segW res_mismatch=res_mismatch flag_cap=flag_cap
    R9 (n9 n10 B) res_pposab l=segL w=segW res_mismatch=res_mismatch flag_cap=flag_cap
    R8 (n8 n9 B) res_pposab l=segL w=segW res_mismatch=res_mismatch flag_cap=flag_cap
    R7 (n7 n8 B) res_pposab l=segL w=segW res_mismatch=res_mismatch flag_cap=flag_cap
    R6 (n6 n7 B) res_pposab l=segL w=segW res_mismatch=res_mismatch flag_cap=flag_cap
    R5 (n5 n6 B) res_pposab l=segL w=segW res_mismatch=res_mismatch flag_cap=flag_cap
    R4 (n4 n5 B) res_pposab l=segL w=segW res_mismatch=res_mismatch flag_cap=flag_cap
    R3 (n3 n4 B) res_pposab l=segL w=segW res_mismatch=res_mismatch flag_cap=flag_cap
    R2 (n2 n3 B) res_pposab l=segL w=segW res_mismatch=res_mismatch flag_cap=flag_cap
    R1 (n1 n2 B) res_pposab l=segL w=segW res_mismatch=res_mismatch flag_cap=flag_cap
    R0 (PLUS n1 B) res_pposab l=segL w=segW res_mismatch=res_mismatch flag_cap=flag_cap
ends res_pposab_pcell_3

// AXS3804_ALF_LDO_DVDD_20mA/pmos_bias/schematic
subckt pmos_bias B D G S
    M201 (net7 G S B) p8ud33io w=(4u) l=2u nf=1 multi=(1) mismatch=1 global_flag=1
    M202 (net8 G net7 B) p8ud33io w=(4u) l=2u nf=1 multi=(1) mismatch=1 global_flag=1
    M203 (net9 G net8 B) p8ud33io w=(4u) l=2u nf=1 multi=(1) mismatch=1 global_flag=1
    M204 (net11 G net9 B) p8ud33io w=(4u) l=2u nf=1 multi=(1) mismatch=1 global_flag=1
    M205 (net10 G net11 B) p8ud33io w=(4u) l=2u nf=1 multi=(1) mismatch=1 global_flag=1
    M206 (D G net10 B) p8ud33io w=(4u) l=2u nf=1 multi=(1) mismatch=1 global_flag=1
ends pmos_bias

// HLMC55HV_ANALOG_BASIC_LOGIC_AI/inv_x2_1p2v/schematic
subckt inv_x2_1p2v DVDD DVSS IN OUT
    PM0 (OUT IN DVDD DVDD) p12 w=(750n) l=54n nf=1 multi=(2) global_flag=0 flag_cpc=1
    PM1 (OUT IN DVSS DVSS) n12 w=(300n) l=54n nf=1 multi=(2) global_flag=0 flag_cpc=1
ends inv_x2_1p2v

// HLMC55HV_ANALOG_BASIC_LOGIC_AI/inv_x2_3p3v/schematic
subckt inv_x2_3p3v AVDD AVSS IN OUT
    M0 (OUT IN AVDD AVDD) p8ud33io w=(2.2u) l=700n nf=1 multi=(2) global_flag=0
    M1 (OUT IN AVSS AVSS) n8ud33io w=(1u) l=800n nf=1 multi=(2) global_flag=0
ends inv_x2_3p3v

// hlmc55hv/res_pposab/schematic
subckt res_pposab_pcell_4 B MINUS PLUS
parameters segL=8u segW=2u res_mismatch=1 flag_cap=1
    R0 (PLUS MINUS B) res_pposab l=segL w=segW res_mismatch=res_mismatch flag_cap=flag_cap
ends res_pposab_pcell_4

// HLMC55HV_ANALOG_BASIC_LOGIC_AI/ls_def1_1p8V/schematic
subckt ls_def1_1p8V AVSS DVDD DVSS IN ISO VDDI Y
    I0 (VDDI AVSS ISO ENB) inv_x1_3p3v
    I4 (VDDI AVSS net018 net021) inv_x1_3p3v
    I3 (VDDI AVSS net8 net018) inv_x1_3p3v
    M1 (net06 ENB VDDI VDDI) p8ud33io w=(800n) l=700n nf=1 multi=(1) global_flag=0
    M2 (net08 net8 net07 VDDI) p8ud33io w=(800n) l=700n nf=1 multi=(1) global_flag=0
    M5 (net8 net3 net03 VDDI) p8ud33io w=(800n) l=700n nf=1 multi=(1) global_flag=0
    M4 (net023 net1 net08 VDDI) p8ud33io w=(800n) l=700n nf=1 multi=(1) global_flag=0
    M3 (net03 net023 net06 VDDI) p8ud33io w=(800n) l=700n nf=1 multi=(1) global_flag=0
    M0 (net07 ENB VDDI VDDI) p8ud33io w=(800n) l=700n nf=1 multi=(1) global_flag=0
    I2 (DVDD DVSS net2 net14) inv_x2_1p2v
    I1 (DVDD DVSS IN net2) inv_x2_1p2v
    I5 (VDDI AVSS net021 Y) inv_x2_3p3v
    NM0 (IN DVSS DVSS DVSS) n12 w=(1u) l=100n nf=1 multi=(1) global_flag=0 flag_cpc=1
    M9 (net1 AVSS AVSS AVSS) n8ud33io w=(800n) l=800n nf=1 multi=(6) global_flag=0
    M10 (net3 AVSS AVSS AVSS) n8ud33io w=(800n) l=800n nf=1 multi=(6) global_flag=0
    M8 (net8 ENB AVSS AVSS) n8ud33io w=(800n) l=800n nf=1 multi=(1) global_flag=0
    M7 (net8 net3 AVSS AVSS) n8ud33io w=(800n) l=800n nf=1 multi=(1) global_flag=0
    M6 (net023 net1 AVSS AVSS) n8ud33io w=(800n) l=800n nf=1 multi=(1) global_flag=0
    R1 (AVSS net3 net14) res_pposab_pcell_4 m=1 segL=2u segW=2u res_mismatch=1 flag_cap=1
    R0 (AVSS net1 net2) res_pposab_pcell_4 m=1 segL=2u segW=2u res_mismatch=1 flag_cap=1
ends ls_def1_1p8V

// HLMC55HV_ANALOG_BASIC_LOGIC_AI/ls_def0_1p8V/schematic
subckt ls_def0_1p8V AVSS DVDD DVSS IN ISO VDDI Y
    NM0 (IN DVSS DVSS DVSS) n12 w=(1u) l=100n nf=1 multi=(1) global_flag=0 flag_cpc=1
    I0 (VDDI AVSS ISO ENB) inv_x1_3p3v
    I3 (VDDI AVSS net8 net3) inv_x1_3p3v
    I4 (VDDI AVSS net3 Y) inv_x2_3p3v
    I2 (DVDD DVSS net13 net15) inv_x2_1p2v
    I1 (DVDD DVSS IN net13) inv_x2_1p2v
    R0 (AVSS net13 net5) res_pposab_pcell_4 m=1 segL=2u segW=2u res_mismatch=1 flag_cap=1
    R1 (AVSS net1 net15) res_pposab_pcell_4 m=1 segL=2u segW=2u res_mismatch=1 flag_cap=1
    M0 (net07 ENB VDDI VDDI) p8ud33io w=(800n) l=700n nf=1 multi=(1) global_flag=0
    M2 (net08 net8 net07 VDDI) p8ud33io w=(800n) l=700n nf=1 multi=(1) global_flag=0
    M3 (net03 net2 net06 VDDI) p8ud33io w=(800n) l=700n nf=1 multi=(1) global_flag=0
    M4 (net2 net1 net08 VDDI) p8ud33io w=(800n) l=700n nf=1 multi=(1) global_flag=0
    M5 (net8 net5 net03 VDDI) p8ud33io w=(800n) l=700n nf=1 multi=(1) global_flag=0
    M1 (net06 ENB VDDI VDDI) p8ud33io w=(800n) l=700n nf=1 multi=(1) global_flag=0
    M8 (net8 ENB AVSS AVSS) n8ud33io w=(800n) l=800n nf=1 multi=(1) global_flag=0
    M10 (net5 AVSS AVSS AVSS) n8ud33io w=(800n) l=800n nf=1 multi=(6) global_flag=0
    M9 (net1 AVSS AVSS AVSS) n8ud33io w=(800n) l=800n nf=1 multi=(6) global_flag=0
    M7 (net8 net5 AVSS AVSS) n8ud33io w=(800n) l=800n nf=1 multi=(1) global_flag=0
    M6 (net2 net1 AVSS AVSS) n8ud33io w=(800n) l=800n nf=1 multi=(1) global_flag=0
ends ls_def0_1p8V

// LDO_AXS/LDO_Core/schematic
subckt LDO_Core AVSS AVSS_DC DVDD DVSS IBP_1UA LDO_DVDD_20mA_EN_VDDI LDO_DVDD_20mA_VADJ_DTA\<3\> LDO_DVDD_20mA_VADJ_DTA\<2\> LDO_DVDD_20mA_VADJ_DTA\<1\> LDO_DVDD_20mA_VADJ_DTA\<0\> LOOP_GAIN_A LOOP_GAIN_B LPBGR_0P5V POC_VDDI VDDI VOUT
    I13 (AVSS VBN2 VBN2 AVSS) nmos_bias
    M50 (net4 EN AVSS AVSS) n8ud33io w=(4u) l=800n nf=1 multi=(1) mismatch=1 global_flag=1
    M49 (net1 ENN AVSS AVSS) n8ud33io w=(4u) l=800n nf=1 multi=(25) mismatch=1 global_flag=1
    M36 (net15 VBN1 AVSS AVSS) n8ud33io w=(4u) l=6u nf=1 multi=(2) mismatch=1 global_flag=1
    M35 (net15 net15 AVSS AVSS) n8ud33io w=(4u) l=2u nf=1 multi=(1) mismatch=1 global_flag=1
    M23 (VBP1 net5 AVSS AVSS) n8ud33io w=(2u) l=3u nf=1 multi=(1) mismatch=1 global_flag=1
    M19 (net17 VBN2 net3 AVSS) n8ud33io w=(4u) l=2u nf=1 multi=(2) mismatch=1 global_flag=1
    M47 (net15 ENN AVSS AVSS) n8ud33io w=(4u) l=800n nf=1 multi=(1) mismatch=1 global_flag=1
    M43 (VBN2 ENN AVSS AVSS) n8ud33io w=(4u) l=800n nf=1 multi=(1) mismatch=1 global_flag=1
    M42 (VBN1 ENN AVSS AVSS) n8ud33io w=(4u) l=800n nf=1 multi=(1) mismatch=1 global_flag=1
    M39 (net5 ENN AVSS AVSS) n8ud33io w=(2u) l=800n nf=1 multi=(1) mismatch=1 global_flag=1
    M25 (net3 VBN1 AVSS AVSS) n8ud33io w=(4u) l=6u nf=1 multi=(3) mismatch=1 global_flag=1
    M18 (VBN1 VBN2 net10 AVSS) n8ud33io w=(4u) l=2u nf=1 multi=(1) mismatch=1 global_flag=1
    M20 (net18 VBN2 net7 AVSS) n8ud33io w=(4u) l=2u nf=1 multi=(2) mismatch=1 global_flag=1
    M26 (net7 VBN1 AVSS AVSS) n8ud33io w=(4u) l=6u nf=1 multi=(3) mismatch=1 global_flag=1
    M24 (net10 VBN1 AVSS AVSS) n8ud33io w=(4u) l=6u nf=1 multi=(1) mismatch=1 global_flag=1
    M22 (VBP2 net5 AVSS AVSS) n8ud33io w=(2u) l=3u nf=1 multi=(1) mismatch=1 global_flag=1
    M21 (net5 net5 AVSS AVSS) n8ud33io w=(2u) l=3u nf=1 multi=(1) mismatch=1 global_flag=1
    M28 (net19 net15 AVSS AVSS) n8ud33io w=(4u) l=2u nf=1 multi=(10) mismatch=1 global_flag=1
    M51 (net18 EN VDDI VDDI) p8ud33io w=(6u) l=700n nf=1 multi=(1) mismatch=1 global_flag=1
    M46 (net19 EN VDDI VDDI) p8ud33io w=(2u) l=700n nf=1 multi=(1) mismatch=1 global_flag=1
    M44 (net17 EN VDDI VDDI) p8ud33io w=(6u) l=700n nf=1 multi=(1) mismatch=1 global_flag=1
    M41 (VBP1 EN VDDI VDDI) p8ud33io w=(6u) l=700n nf=1 multi=(1) mismatch=1 global_flag=1
    M40 (VBP2 EN VDDI VDDI) p8ud33io w=(4u) l=700n nf=1 multi=(1) mismatch=1 global_flag=1
    M34 (net15 net18 VDDI VDDI) p8ud33io w=(2u) l=1u nf=1 multi=(4) mismatch=1 global_flag=1
    M10 (VBN2 VBP2 net11 VDDI) p8ud33io w=(4u) l=2u nf=1 multi=(1) mismatch=1 global_flag=1
    M3 (net2 VBP1 VDDI VDDI) p8ud33io w=(6u) l=2u nf=1 multi=(2) mismatch=1 global_flag=1
    M2 (net8 VBP1 VDDI VDDI) p8ud33io w=(6u) l=2u nf=1 multi=(1) mismatch=1 global_flag=1
    M11 (VBN1 VBP2 net8 VDDI) p8ud33io w=(4u) l=2u nf=1 multi=(1) mismatch=1 global_flag=1
    M5 (net18 net17 VDDI VDDI) p8ud33io w=(6u) l=2u nf=1 multi=(2) mismatch=1 global_flag=1
    M9 (VBP1 VBP2 net12 VDDI) p8ud33io w=(4u) l=2u nf=1 multi=(1) mismatch=1 global_flag=1
    M1 (net11 VBP1 VDDI VDDI) p8ud33io w=(6u) l=2u nf=1 multi=(1) mismatch=1 global_flag=1
    M16 (net7 LPBGR_0P5V net2 VDDI) p8ud33io w=(5u) l=1u nf=1 multi=(16) mismatch=1 global_flag=1
    M15 (net3 LOOP_GAIN_B net2 VDDI) p8ud33io w=(5u) l=1u nf=1 multi=(16) mismatch=1 global_flag=1
    M7 (VOUT net19 VDDI VDDI) p8ud33io w=(33u) l=700n nf=1 multi=(120) mismatch=1 global_flag=1
    M6 (net19 net19 VDDI VDDI) p8ud33io w=(2u) l=1u nf=1 multi=(1) mismatch=1 global_flag=1
    M0 (net12 VBP1 VDDI VDDI) p8ud33io w=(6u) l=2u nf=1 multi=(1) mismatch=1 global_flag=1
    M4 (net17 net17 VDDI VDDI) p8ud33io w=(6u) l=2u nf=1 multi=(2) mismatch=1 global_flag=1
    I0 (IBP_1UA VDDI AVSS net5 EN) tg_x1_3p3v
    C0 (net7 VOUT) mom23 lr=5u nf=100 mr=24 mom_mismatch=1
    C2 (VDDI net18) mom23 lr=5u nf=100 mr=9
    I2 (LOOP_GAIN_A AVSS AVSS_DC) RES_FB
    I3 (VOUT AVSS LOOP_GAIN_A RES_ADJ\<3\> RES_ADJ\<2\> RES_ADJ\<1\> RES_ADJ\<0\>) RES_ADJ
    R2 (AVSS net1 VOUT) res_pposab_pcell_1 m=1 segL=5u segW=1u res_mismatch=1 flag_cap=1
    R0 (AVSS net19 VDDI) res_pposab_pcell_2 m=1 segL=8u segW=2u res_mismatch=1 flag_cap=1
    R1 (AVSS net4 VOUT) res_pposab_pcell_3 m=1 segL=5u segW=1u res_mismatch=1 flag_cap=1
    I12 (VDDI AVSS ENN EN) inv_x1_3p3v
    I1 (VDDI AVSS LDO_DVDD_20mA_EN_VDDI ENN) inv_x1_3p3v
    I14 (VDDI VBP2 VBP2 VDDI) pmos_bias
    I8 (AVSS DVDD DVSS LDO_DVDD_20mA_VADJ_DTA\<3\> POC_VDDI VDDI RES_ADJ\<3\>) ls_def1_1p8V
    I9 (AVSS DVDD DVSS LDO_DVDD_20mA_VADJ_DTA\<0\> POC_VDDI VDDI RES_ADJ\<0\>) ls_def1_1p8V
    I11 (AVSS DVDD DVSS LDO_DVDD_20mA_VADJ_DTA\<1\> POC_VDDI VDDI RES_ADJ\<1\>) ls_def0_1p8V
    I10 (AVSS DVDD DVSS LDO_DVDD_20mA_VADJ_DTA\<2\> POC_VDDI VDDI RES_ADJ\<2\>) ls_def0_1p8V
ends LDO_Core

// LDO_AXS/tb_Stability/schematic
V17 (DVSS 0) vsource dc=0 type=dc
V16 (DVDD AVSS) vsource dc=DVDD type=dc
V14 (POC_VDDI AVSS) vsource dc=POC_VDDI type=dc
V13 (RES_ADJ\<2\> AVSS) vsource dc=V2 type=dc
V12 (RES_ADJ\<3\> AVSS) vsource dc=V3 type=dc
V11 (RES_ADJ\<1\> AVSS) vsource dc=V1 type=dc
V10 (RES_ADJ\<0\> AVSS) vsource dc=V0 type=dc
V9 (EN AVSS) vsource dc=EN type=dc
V4 (net13 net4) vsource dc=0 mag=0 type=dc
V3 (LPBGR_0P5V AVSS) vsource dc=VREF mag=1 type=dc
V2 (VDDI AVSS) vsource dc=VDDI type=dc
V0 (AVSS 0) vsource dc=0 type=dc
I6 (net24 AVSS) isource dc=1u type=dc
I1 (net23 AVSS) isource dc=1u type=dc
C2 (net7 AVSS) capacitor c=2.2u
C1 (net4 AVSS) capacitor c=100M
C0 (net2 AVSS) capacitor c=2.2u
R5 (net6 AVSS) resistor r=r_load
R4 (net6 net8) resistor r=3
R3 (net8 net7) resistor r=40m
R2 (net3 AVSS) resistor r=r_load
R1 (net3 net1) resistor r=ESR
R0 (net1 net2) resistor r=40m
L0 (net4 net5) inductor l=100M
IPRB0 (net9 net18) iprobe
M6 (net28 net27 VDDI VDDI) p8ud33io w=(5u) l=2u nf=1 multi=(2) global_flag=0
M5 (net27 net27 VDDI VDDI) p8ud33io w=(5u) l=2u nf=1 multi=(2) global_flag=0
M4 (IBP1_1uA net24 net28 VDDI) p8ud33io w=(5u) l=2u nf=1 multi=(1) global_flag=0
M0 (IBP_1uA net23 net26 VDDI) p8ud33io w=(5u) l=2u nf=1 multi=(1) global_flag=0
M2 (net25 net25 VDDI VDDI) p8ud33io w=(5u) l=2u nf=1 multi=(2) global_flag=0
M11 (net23 net23 net25 VDDI) p8ud33io w=(5u) l=2u nf=1 multi=(1) global_flag=0
M3 (net24 net24 net27 VDDI) p8ud33io w=(5u) l=2u nf=1 multi=(1) global_flag=0
M1 (net26 net25 VDDI VDDI) p8ud33io w=(5u) l=2u nf=1 multi=(2) global_flag=0
I4 (AVSS AVSS DVDD DVSS IBP1_1uA EN RES_ADJ\<3\> RES_ADJ\<2\> RES_ADJ\<1\> RES_ADJ\<0\> net18 net9 LPBGR_0P5V POC_VDDI VDDI net6) LDO_Core
I0 (AVSS AVSS DVDD DVSS IBP_1uA EN RES_ADJ\<3\> RES_ADJ\<2\> RES_ADJ\<1\> RES_ADJ\<0\> net5 net13 LPBGR_0P5V POC_VDDI VDDI net3) LDO_Core
simulatorOptions options temp=125.0
dcOp dc
ac ac start=0.1 stop=1G
stb stb start=0.1 stop=1G probe=IPRB0 localgnd=AVSS
