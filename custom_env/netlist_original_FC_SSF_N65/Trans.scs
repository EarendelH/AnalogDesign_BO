// Design: LDO_FC_SSF_N65/tb_Trans
simulator lang=spectre
global 0
parameters CAP_CMP IBN_EA RES_CMP VB_1 VB_2
include "/data/PDK/pdk_installed/tsmc65_gp/tsmcN65/../models/spectre/crn65gplus_2d5_lk_v1d0.scs" section=tt_bip
include "/data/PDK/pdk_installed/tsmc65_gp/tsmcN65/../models/spectre/crn65gplus_2d5_lk_v1d0.scs" section=tt_dio
include "/data/PDK/pdk_installed/tsmc65_gp/tsmcN65/../models/spectre/crn65gplus_2d5_lk_v1d0.scs" section=tt_dio_33
include "/data/PDK/pdk_installed/tsmc65_gp/tsmcN65/../models/spectre/crn65gplus_2d5_lk_v1d0.scs" section=tt_mim
include "/data/PDK/pdk_installed/tsmc65_gp/tsmcN65/../models/spectre/crn65gplus_2d5_lk_v1d0.scs" section=tt_dio_dnw
include "/data/PDK/pdk_installed/tsmc65_gp/tsmcN65/../models/spectre/crn65gplus_2d5_lk_v1d0.scs" section=tt_dio_18
include "/data/PDK/pdk_installed/tsmc65_gp/tsmcN65/../models/spectre/crn65gplus_2d5_lk_v1d0.scs" section=tt_bip_npn
include "/data/PDK/pdk_installed/tsmc65_gp/tsmcN65/../models/spectre/crn65gplus_2d5_lk_v1d0.scs" section=tt_33
include "/data/PDK/pdk_installed/tsmc65_gp/tsmcN65/../models/spectre/crn65gplus_2d5_lk_v1d0.scs" section=tt_rfrtmom
include "/data/PDK/pdk_installed/tsmc65_gp/tsmcN65/../models/spectre/crn65gplus_2d5_lk_v1d0.scs" section=tt_mos_cap_25
include "/data/PDK/pdk_installed/tsmc65_gp/tsmcN65/../models/spectre/crn65gplus_2d5_lk_v1d0.scs" section=tt_18
include "/data/PDK/pdk_installed/tsmc65_gp/tsmcN65/../models/spectre/crn65gplus_2d5_lk_v1d0.scs" section=tt_disres
include "/data/PDK/pdk_installed/tsmc65_gp/tsmcN65/../models/spectre/crn65gplus_2d5_lk_v1d0.scs" section=tt_res
include "/data/PDK/pdk_installed/tsmc65_gp/tsmcN65/../models/spectre/crn65gplus_2d5_lk_v1d0.scs" section=tt_dio_na
include "/data/PDK/pdk_installed/tsmc65_gp/tsmcN65/../models/spectre/crn65gplus_2d5_lk_v1d0.scs" section=tt_rfmos_33
include "/data/PDK/pdk_installed/tsmc65_gp/tsmcN65/../models/spectre/crn65gplus_2d5_lk_v1d0.scs" section=tt_dio_hvt
include "/data/PDK/pdk_installed/tsmc65_gp/tsmcN65/../models/spectre/crn65gplus_2d5_lk_v1d0.scs" section=tt_rfmvar
include "/data/PDK/pdk_installed/tsmc65_gp/tsmcN65/../models/spectre/crn65gplus_2d5_lk_v1d0.scs" section=tt_rfmos_18
include "/data/PDK/pdk_installed/tsmc65_gp/tsmcN65/../models/spectre/crn65gplus_2d5_lk_v1d0.scs" section=tt_na
include "/data/PDK/pdk_installed/tsmc65_gp/tsmcN65/../models/spectre/crn65gplus_2d5_lk_v1d0.scs" section=tt_dio_na33
include "/data/PDK/pdk_installed/tsmc65_gp/tsmcN65/../models/spectre/crn65gplus_2d5_lk_v1d0.scs" section=tt_dio_lvt
include "/data/PDK/pdk_installed/tsmc65_gp/tsmcN65/../models/spectre/crn65gplus_2d5_lk_v1d0.scs" section=tt_rfres_sa
include "/data/PDK/pdk_installed/tsmc65_gp/tsmcN65/../models/spectre/crn65gplus_2d5_lk_v1d0.scs" section=tt_na33
include "/data/PDK/pdk_installed/tsmc65_gp/tsmcN65/../models/spectre/crn65gplus_2d5_lk_v1d0.scs" section=tt_dio_esd
include "/data/PDK/pdk_installed/tsmc65_gp/tsmcN65/../models/spectre/crn65gplus_2d5_lk_v1d0.scs" section=tt_rfmim
include "/data/PDK/pdk_installed/tsmc65_gp/tsmcN65/../models/spectre/crn65gplus_2d5_lk_v1d0.scs" section=tt_dio_25od33
include "/data/PDK/pdk_installed/tsmc65_gp/tsmcN65/../models/spectre/crn65gplus_2d5_lk_v1d0.scs" section=tt_25od33
include "/data/PDK/pdk_installed/tsmc65_gp/tsmcN65/../models/spectre/crn65gplus_2d5_lk_v1d0.scs" section=tt
include "/data/PDK/pdk_installed/tsmc65_gp/tsmcN65/../models/spectre/crn65gplus_2d5_lk_v1d0.scs" section=tt_mos_cap
include "/data/PDK/pdk_installed/tsmc65_gp/tsmcN65/../models/spectre/crn65gplus_2d5_lk_v1d0.scs" section=tt_dio_25
include "/data/PDK/pdk_installed/tsmc65_gp/tsmcN65/../models/spectre/crn65gplus_2d5_lk_v1d0.scs" section=tt_dio_25ud18
include "/data/PDK/pdk_installed/tsmc65_gp/tsmcN65/../models/spectre/crn65gplus_2d5_lk_v1d0.scs" section=tt_25
include "/data/PDK/pdk_installed/tsmc65_gp/tsmcN65/../models/spectre/crn65gplus_2d5_lk_v1d0.scs" section=tt_rfmos
include "/data/PDK/pdk_installed/tsmc65_gp/tsmcN65/../models/spectre/crn65gplus_2d5_lk_v1d0.scs" section=tt_25ud18
include "/data/PDK/pdk_installed/tsmc65_gp/tsmcN65/../models/spectre/crn65gplus_2d5_lk_v1d0.scs" section=tt_dio_na25od33
include "/data/PDK/pdk_installed/tsmc65_gp/tsmcN65/../models/spectre/crn65gplus_2d5_lk_v1d0.scs" section=tt_rfjvar
include "/data/PDK/pdk_installed/tsmc65_gp/tsmcN65/../models/spectre/crn65gplus_2d5_lk_v1d0.scs" section=tt_rfmos_25
include "/data/PDK/pdk_installed/tsmc65_gp/tsmcN65/../models/spectre/crn65gplus_2d5_lk_v1d0.scs" section=tt_rtmom
include "/data/PDK/pdk_installed/tsmc65_gp/tsmcN65/../models/spectre/crn65gplus_2d5_lk_v1d0.scs" section=tt_na25od33
include "/data/PDK/pdk_installed/tsmc65_gp/tsmcN65/../models/spectre/crn65gplus_2d5_lk_v1d0.scs" section=tt_dio_na25
include "/data/PDK/pdk_installed/tsmc65_gp/tsmcN65/../models/spectre/crn65gplus_2d5_lk_v1d0.scs" section=tt_rfres_rpo
include "/data/PDK/pdk_installed/tsmc65_gp/tsmcN65/../models/spectre/crn65gplus_2d5_lk_v1d0.scs" section=tt_hvt
include "/data/PDK/pdk_installed/tsmc65_gp/tsmcN65/../models/spectre/crn65gplus_2d5_lk_v1d0.scs" section=tt_rfind
include "/data/PDK/pdk_installed/tsmc65_gp/tsmcN65/../models/spectre/crn65gplus_2d5_lk_v1d0.scs" section=tt_rfmvar_25
include "/data/PDK/pdk_installed/tsmc65_gp/tsmcN65/../models/spectre/crn65gplus_2d5_lk_v1d0.scs" section=tt_na25
include "/data/PDK/pdk_installed/tsmc65_gp/tsmcN65/../models/spectre/crn65gplus_2d5_lk_v1d0.scs" section=tt_lvt

// LDO_FC_SSF_N65/EA_Core/schematic
subckt EA_Core IBN_EA VB_1 VB_2 VDD VEA VFB VG VREF VSS
    M1 (net125 VFB net66 net66) nch_mac l=500n w=5u multi=6 nf=1 sigma=1 mismatchflag=1
    M25 (VG IBP_BUF2 VSS VSS) nch_mac l=500n w=5u multi=6 nf=1 sigma=1 mismatchflag=1
    M18 (VEA VB_1 net127 VSS) nch_mac l=500n w=5u multi=6 nf=1 sigma=1 mismatchflag=1
    M17 (net126 VB_1 net124 VSS) nch_mac l=500n w=5u multi=6 nf=1 sigma=1 mismatchflag=1
    M16 (IBN_EA IBN_EA VSS VSS) nch_mac l=500n w=5u multi=6 nf=1 sigma=1 mismatchflag=1
    M13 (net66 IBN_EA VSS VSS) nch_mac l=500n w=5u multi=6 nf=1 sigma=1 mismatchflag=1
    M12 (IBP_BUF2 IBN_EA VSS VSS) nch_mac l=500n w=5u multi=6 nf=1 sigma=1 mismatchflag=1
    M8 (IBP_BUF1 IBN_EA VSS VSS) nch_mac l=500n w=5u multi=6 nf=1 sigma=1 mismatchflag=1
    M7 (net127 net126 VSS VSS) nch_mac l=500n w=5u multi=6 nf=1 sigma=1 mismatchflag=1
    M6 (net124 net126 VSS VSS) nch_mac l=500n w=5u multi=6 nf=1 sigma=1 mismatchflag=1
    M4 (VBP_TAIL IBN_EA VSS VSS) nch_mac l=500n w=5u multi=6 nf=1 sigma=1 mismatchflag=1
    M2 (net128 VREF net66 net66) nch_mac l=500n w=5u multi=6 nf=1 sigma=1 mismatchflag=1
    M5 (IBP_BUF1 IBP_BUF1 VDD VDD) pch_mac l=500n w=200n multi=1 nf=1 sigma=1 mismatchflag=1
    M26 (net128 VBP_TAIL VDD VDD) pch_mac l=500n w=4u multi=3 nf=1 sigma=1 mismatchflag=1
    M24 (VEA VB_2 net128 VDD) pch_mac l=500n w=4u multi=2 nf=1 sigma=1 mismatchflag=1
    M19 (net126 VB_2 net125 VDD) pch_mac l=500n w=4u multi=2 nf=1 sigma=1 mismatchflag=1
    M15 (VBP_TAIL VBP_TAIL VDD VDD) pch_mac l=500n w=4u multi=1 nf=1 sigma=1 mismatchflag=1
    M14 (net125 VBP_TAIL VDD VDD) pch_mac l=500n w=4u multi=3 nf=1 sigma=1 mismatchflag=1
    M9 (VG IBP_BUF1 VDD VDD) pch_mac l=500n w=200n multi=2 nf=1 sigma=1 mismatchflag=1
    M3 (IBP_BUF2 VEA VG VDD) pch_mac l=500n w=200n multi=4 nf=1 sigma=1 mismatchflag=1
ends EA_Core

// LDO_FC_SSF_N65/tb_Trans/schematic
M0 (VOUT VG VDD VDD) pch_mac l=180.0n w=12.000m multi=1 nf=600 sigma=1 mismatchflag=1
V1 (VB_2 VSS) vsource dc=VB_2 type=dc
VIN2 (VDD 0) vsource dc=1.2 type=dc
V3 (VSS 0) vsource dc=0 type=dc
V0 (VB_1 VSS) vsource dc=VB_1 type=dc
V2 (VREF VSS) vsource dc=1 type=dc
I4 (VREF IBN_EA) isource dc=IBN_EA type=dc
C1 (VEA net016) capacitor c=CAP_CMP
C0 (VOUT VSS) capacitor c=1n
R0 (net016 VOUT) resistor r=RES_CMP
I8 (IBN_EA VB_1 VB_2 VDD VEA VOUT VG VREF VSS) EA_Core
I1 (VOUT VSS) isource type=pulse val0=1m val1=100m period=10u delay=5u rise=100n fall=100n width=5u
simulatorOptions options temp=27
tran tran stop=15u errpreset=conservative
