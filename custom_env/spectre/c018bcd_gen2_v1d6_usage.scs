section pre_simu
parOpt options redefinedparams=ignore
parameters ccoflag=1
parameters ccoflag_5=1
parameters ccoflag_5_fgd=1
parameters ccoflag_5_lvt=1
parameters ccoflag_5_switch=1
parameters ccoflag_5vna=1
parameters ccoflag_dep5=1
parameters ccoflag_na=1
endsection pre_simu

section tt_lib
include "c018bcd_gen2_v1d6.scs" section=tt
include "c018bcd_gen2_v1d6.scs" section=tt_5
include "c018bcd_gen2_v1d6.scs" section=tt_5_fgd
include "c018bcd_gen2_v1d6.scs" section=tt_5_lvt
include "c018bcd_gen2_v1d6.scs" section=tt_5_switch
include "c018bcd_gen2_v1d6.scs" section=tt_5vna
include "c018bcd_gen2_v1d6.scs" section=tt_bbmvar
include "c018bcd_gen2_v1d6.scs" section=tt_bbmvar5
include "c018bcd_gen2_v1d6.scs" section=tt_bip
include "c018bcd_gen2_v1d6.scs" section=tt_bip5_poly
include "c018bcd_gen2_v1d6.scs" section=tt_bip5_rpo
include "c018bcd_gen2_v1d6.scs" section=tt_bip_hv
include "c018bcd_gen2_v1d6.scs" section=tt_bip_rpo
include "c018bcd_gen2_v1d6.scs" section=tt_dep5
include "c018bcd_gen2_v1d6.scs" section=tt_dio
include "c018bcd_gen2_v1d6.scs" section=tt_dio_5
include "c018bcd_gen2_v1d6.scs" section=tt_dio_esd
include "c018bcd_gen2_v1d6.scs" section=tt_dio_hv
include "c018bcd_gen2_v1d6.scs" section=tt_dio_sbd_zd
include "c018bcd_gen2_v1d6.scs" section=tt_disres
include "c018bcd_gen2_v1d6.scs" section=tt_fmom
include "c018bcd_gen2_v1d6.scs" section=tt_hv
include "c018bcd_gen2_v1d6.scs" section=tt_hv5_5vnw
include "c018bcd_gen2_v1d6.scs" section=tt_mim
include "c018bcd_gen2_v1d6.scs" section=tt_na
include "c018bcd_gen2_v1d6.scs" section=tt_res
include "c018bcd_gen2_v1d6.scs" section=tt_res_hv
include "c018bcd_gen2_v1d6.scs" section=tt_rtmom
include "c018bcd_gen2_v1d6.scs" section=stat_noise
parOpt options redefinedparams=ignore
parameters mismatchflag_bip5_poly=0
parameters mismatchflag_bip5_rpo=0
parameters mismatchflag_bip=0
parameters mismatchflag_bip_hv=0
parameters mismatchflag_bip_rpo=0
parameters mismatchflag_cap5=0
parameters mismatchflag_disres=0
parameters mismatchflag_fmom=0
parameters mismatchflag_hv=0
parameters mismatchflag_mim=0
parameters mismatchflag_mos=0
parameters mismatchflag_mos_5=0
parameters mismatchflag_mos_5_fgd=0
parameters mismatchflag_mos_5_lvt=0
parameters mismatchflag_mos_5vna=0
parameters mismatchflag_mos_dep5=0
parameters mismatchflag_mos_na=0
parameters mismatchflag_res=0
parameters mismatchflag_res_hv=0
parameters mismatchflag_rtmom=0
endsection tt_lib

section ss_lib
include "c018bcd_gen2_v1d6.scs" section=ss
include "c018bcd_gen2_v1d6.scs" section=ss_5
include "c018bcd_gen2_v1d6.scs" section=ss_5_fgd
include "c018bcd_gen2_v1d6.scs" section=ss_5_lvt
include "c018bcd_gen2_v1d6.scs" section=ss_5_switch
include "c018bcd_gen2_v1d6.scs" section=ss_5vna
include "c018bcd_gen2_v1d6.scs" section=ss_bbmvar
include "c018bcd_gen2_v1d6.scs" section=ss_bbmvar5
include "c018bcd_gen2_v1d6.scs" section=ss_bip
include "c018bcd_gen2_v1d6.scs" section=ss_bip5_poly
include "c018bcd_gen2_v1d6.scs" section=ss_bip5_rpo
include "c018bcd_gen2_v1d6.scs" section=ss_bip_hv
include "c018bcd_gen2_v1d6.scs" section=ss_bip_rpo
include "c018bcd_gen2_v1d6.scs" section=ss_dep5
include "c018bcd_gen2_v1d6.scs" section=ss_dio
include "c018bcd_gen2_v1d6.scs" section=ss_dio_5
include "c018bcd_gen2_v1d6.scs" section=ss_dio_esd
include "c018bcd_gen2_v1d6.scs" section=ss_dio_hv
include "c018bcd_gen2_v1d6.scs" section=ss_dio_sbd_zd
include "c018bcd_gen2_v1d6.scs" section=ss_disres
include "c018bcd_gen2_v1d6.scs" section=ss_fmom
include "c018bcd_gen2_v1d6.scs" section=ss_hv
include "c018bcd_gen2_v1d6.scs" section=ss_hv5_5vnw
include "c018bcd_gen2_v1d6.scs" section=ss_mim
include "c018bcd_gen2_v1d6.scs" section=ss_na
include "c018bcd_gen2_v1d6.scs" section=ss_res
include "c018bcd_gen2_v1d6.scs" section=ss_res_hv
include "c018bcd_gen2_v1d6.scs" section=ss_rtmom
include "c018bcd_gen2_v1d6.scs" section=stat_noise
parOpt options redefinedparams=ignore
parameters mismatchflag_bip5_poly=0
parameters mismatchflag_bip5_rpo=0
parameters mismatchflag_bip=0
parameters mismatchflag_bip_hv=0
parameters mismatchflag_bip_rpo=0
parameters mismatchflag_cap5=0
parameters mismatchflag_disres=0
parameters mismatchflag_fmom=0
parameters mismatchflag_hv=0
parameters mismatchflag_mim=0
parameters mismatchflag_mos=0
parameters mismatchflag_mos_5=0
parameters mismatchflag_mos_5_fgd=0
parameters mismatchflag_mos_5_lvt=0
parameters mismatchflag_mos_5vna=0
parameters mismatchflag_mos_dep5=0
parameters mismatchflag_mos_na=0
parameters mismatchflag_res=0
parameters mismatchflag_res_hv=0
parameters mismatchflag_rtmom=0
endsection ss_lib

section ff_lib
include "c018bcd_gen2_v1d6.scs" section=ff
include "c018bcd_gen2_v1d6.scs" section=ff_5
include "c018bcd_gen2_v1d6.scs" section=ff_5_fgd
include "c018bcd_gen2_v1d6.scs" section=ff_5_lvt
include "c018bcd_gen2_v1d6.scs" section=ff_5_switch
include "c018bcd_gen2_v1d6.scs" section=ff_5vna
include "c018bcd_gen2_v1d6.scs" section=ff_bbmvar
include "c018bcd_gen2_v1d6.scs" section=ff_bbmvar5
include "c018bcd_gen2_v1d6.scs" section=ff_bip
include "c018bcd_gen2_v1d6.scs" section=ff_bip5_poly
include "c018bcd_gen2_v1d6.scs" section=ff_bip5_rpo
include "c018bcd_gen2_v1d6.scs" section=ff_bip_hv
include "c018bcd_gen2_v1d6.scs" section=ff_bip_rpo
include "c018bcd_gen2_v1d6.scs" section=ff_dep5
include "c018bcd_gen2_v1d6.scs" section=ff_dio
include "c018bcd_gen2_v1d6.scs" section=ff_dio_5
include "c018bcd_gen2_v1d6.scs" section=ff_dio_esd
include "c018bcd_gen2_v1d6.scs" section=ff_dio_hv
include "c018bcd_gen2_v1d6.scs" section=ff_dio_sbd_zd
include "c018bcd_gen2_v1d6.scs" section=ff_disres
include "c018bcd_gen2_v1d6.scs" section=ff_fmom
include "c018bcd_gen2_v1d6.scs" section=ff_hv
include "c018bcd_gen2_v1d6.scs" section=ff_hv5_5vnw
include "c018bcd_gen2_v1d6.scs" section=ff_mim
include "c018bcd_gen2_v1d6.scs" section=ff_na
include "c018bcd_gen2_v1d6.scs" section=ff_res
include "c018bcd_gen2_v1d6.scs" section=ff_res_hv
include "c018bcd_gen2_v1d6.scs" section=ff_rtmom
include "c018bcd_gen2_v1d6.scs" section=stat_noise
parOpt options redefinedparams=ignore
parameters mismatchflag_bip5_poly=0
parameters mismatchflag_bip5_rpo=0
parameters mismatchflag_bip=0
parameters mismatchflag_bip_hv=0
parameters mismatchflag_bip_rpo=0
parameters mismatchflag_cap5=0
parameters mismatchflag_disres=0
parameters mismatchflag_fmom=0
parameters mismatchflag_hv=0
parameters mismatchflag_mim=0
parameters mismatchflag_mos=0
parameters mismatchflag_mos_5=0
parameters mismatchflag_mos_5_fgd=0
parameters mismatchflag_mos_5_lvt=0
parameters mismatchflag_mos_5vna=0
parameters mismatchflag_mos_dep5=0
parameters mismatchflag_mos_na=0
parameters mismatchflag_res=0
parameters mismatchflag_res_hv=0
parameters mismatchflag_rtmom=0
endsection ff_lib

section sf_lib
include "c018bcd_gen2_v1d6.scs" section=sf
include "c018bcd_gen2_v1d6.scs" section=sf_5
include "c018bcd_gen2_v1d6.scs" section=sf_5_fgd
include "c018bcd_gen2_v1d6.scs" section=sf_5_lvt
include "c018bcd_gen2_v1d6.scs" section=sf_5_switch
include "c018bcd_gen2_v1d6.scs" section=sf_5vna
include "c018bcd_gen2_v1d6.scs" section=sf_dep5
include "c018bcd_gen2_v1d6.scs" section=sf_hv
include "c018bcd_gen2_v1d6.scs" section=sf_hv5_5vnw
include "c018bcd_gen2_v1d6.scs" section=sf_na
include "c018bcd_gen2_v1d6.scs" section=tt_bbmvar
include "c018bcd_gen2_v1d6.scs" section=tt_bbmvar5
include "c018bcd_gen2_v1d6.scs" section=tt_bip
include "c018bcd_gen2_v1d6.scs" section=tt_bip5_poly
include "c018bcd_gen2_v1d6.scs" section=tt_bip5_rpo
include "c018bcd_gen2_v1d6.scs" section=tt_bip_hv
include "c018bcd_gen2_v1d6.scs" section=tt_bip_rpo
include "c018bcd_gen2_v1d6.scs" section=tt_dio
include "c018bcd_gen2_v1d6.scs" section=tt_dio_5
include "c018bcd_gen2_v1d6.scs" section=tt_dio_esd
include "c018bcd_gen2_v1d6.scs" section=tt_dio_hv
include "c018bcd_gen2_v1d6.scs" section=tt_dio_sbd_zd
include "c018bcd_gen2_v1d6.scs" section=tt_disres
include "c018bcd_gen2_v1d6.scs" section=tt_fmom
include "c018bcd_gen2_v1d6.scs" section=tt_mim
include "c018bcd_gen2_v1d6.scs" section=tt_res
include "c018bcd_gen2_v1d6.scs" section=tt_res_hv
include "c018bcd_gen2_v1d6.scs" section=tt_rtmom
include "c018bcd_gen2_v1d6.scs" section=stat_noise
parOpt options redefinedparams=ignore
parameters mismatchflag_bip5_poly=0
parameters mismatchflag_bip5_rpo=0
parameters mismatchflag_bip=0
parameters mismatchflag_bip_hv=0
parameters mismatchflag_bip_rpo=0
parameters mismatchflag_cap5=0
parameters mismatchflag_disres=0
parameters mismatchflag_fmom=0
parameters mismatchflag_hv=0
parameters mismatchflag_mim=0
parameters mismatchflag_mos=0
parameters mismatchflag_mos_5=0
parameters mismatchflag_mos_5_fgd=0
parameters mismatchflag_mos_5_lvt=0
parameters mismatchflag_mos_5vna=0
parameters mismatchflag_mos_dep5=0
parameters mismatchflag_mos_na=0
parameters mismatchflag_res=0
parameters mismatchflag_res_hv=0
parameters mismatchflag_rtmom=0
endsection sf_lib

section fs_lib
include "c018bcd_gen2_v1d6.scs" section=fs
include "c018bcd_gen2_v1d6.scs" section=fs_5
include "c018bcd_gen2_v1d6.scs" section=fs_5_fgd
include "c018bcd_gen2_v1d6.scs" section=fs_5_lvt
include "c018bcd_gen2_v1d6.scs" section=fs_5_switch
include "c018bcd_gen2_v1d6.scs" section=fs_5vna
include "c018bcd_gen2_v1d6.scs" section=fs_dep5
include "c018bcd_gen2_v1d6.scs" section=fs_hv
include "c018bcd_gen2_v1d6.scs" section=fs_hv5_5vnw
include "c018bcd_gen2_v1d6.scs" section=fs_na
include "c018bcd_gen2_v1d6.scs" section=tt_bbmvar
include "c018bcd_gen2_v1d6.scs" section=tt_bbmvar5
include "c018bcd_gen2_v1d6.scs" section=tt_bip
include "c018bcd_gen2_v1d6.scs" section=tt_bip5_poly
include "c018bcd_gen2_v1d6.scs" section=tt_bip5_rpo
include "c018bcd_gen2_v1d6.scs" section=tt_bip_hv
include "c018bcd_gen2_v1d6.scs" section=tt_bip_rpo
include "c018bcd_gen2_v1d6.scs" section=tt_dio
include "c018bcd_gen2_v1d6.scs" section=tt_dio_5
include "c018bcd_gen2_v1d6.scs" section=tt_dio_esd
include "c018bcd_gen2_v1d6.scs" section=tt_dio_hv
include "c018bcd_gen2_v1d6.scs" section=tt_dio_sbd_zd
include "c018bcd_gen2_v1d6.scs" section=tt_disres
include "c018bcd_gen2_v1d6.scs" section=tt_fmom
include "c018bcd_gen2_v1d6.scs" section=tt_mim
include "c018bcd_gen2_v1d6.scs" section=tt_res
include "c018bcd_gen2_v1d6.scs" section=tt_res_hv
include "c018bcd_gen2_v1d6.scs" section=tt_rtmom
include "c018bcd_gen2_v1d6.scs" section=stat_noise
parOpt options redefinedparams=ignore
parameters mismatchflag_bip5_poly=0
parameters mismatchflag_bip5_rpo=0
parameters mismatchflag_bip=0
parameters mismatchflag_bip_hv=0
parameters mismatchflag_bip_rpo=0
parameters mismatchflag_cap5=0
parameters mismatchflag_disres=0
parameters mismatchflag_fmom=0
parameters mismatchflag_hv=0
parameters mismatchflag_mim=0
parameters mismatchflag_mos=0
parameters mismatchflag_mos_5=0
parameters mismatchflag_mos_5_fgd=0
parameters mismatchflag_mos_5_lvt=0
parameters mismatchflag_mos_5vna=0
parameters mismatchflag_mos_dep5=0
parameters mismatchflag_mos_na=0
parameters mismatchflag_res=0
parameters mismatchflag_res_hv=0
parameters mismatchflag_rtmom=0
endsection fs_lib

section mc_lib
include "c018bcd_gen2_v1d6.scs" section=mc
include "c018bcd_gen2_v1d6.scs" section=mc_5
include "c018bcd_gen2_v1d6.scs" section=mc_5_fgd
include "c018bcd_gen2_v1d6.scs" section=mc_5_lvt
include "c018bcd_gen2_v1d6.scs" section=mc_5_switch
include "c018bcd_gen2_v1d6.scs" section=mc_5vna
include "c018bcd_gen2_v1d6.scs" section=mc_bbmvar
include "c018bcd_gen2_v1d6.scs" section=mc_bbmvar5
include "c018bcd_gen2_v1d6.scs" section=mc_bip
include "c018bcd_gen2_v1d6.scs" section=mc_bip5_poly
include "c018bcd_gen2_v1d6.scs" section=mc_bip5_rpo
include "c018bcd_gen2_v1d6.scs" section=mc_bip_hv
include "c018bcd_gen2_v1d6.scs" section=mc_bip_rpo
include "c018bcd_gen2_v1d6.scs" section=mc_dep5
include "c018bcd_gen2_v1d6.scs" section=mc_disres
include "c018bcd_gen2_v1d6.scs" section=mc_fmom
include "c018bcd_gen2_v1d6.scs" section=mc_mim
include "c018bcd_gen2_v1d6.scs" section=mc_na
include "c018bcd_gen2_v1d6.scs" section=mc_res
include "c018bcd_gen2_v1d6.scs" section=mc_res_hv
include "c018bcd_gen2_v1d6.scs" section=mc_rtmom
include "c018bcd_gen2_v1d6.scs" section=tt_dio
include "c018bcd_gen2_v1d6.scs" section=tt_dio_5
include "c018bcd_gen2_v1d6.scs" section=tt_dio_esd
include "c018bcd_gen2_v1d6.scs" section=tt_dio_hv
include "c018bcd_gen2_v1d6.scs" section=tt_dio_sbd_zd
include "c018bcd_gen2_v1d6.scs" section=tt_hv
include "c018bcd_gen2_v1d6.scs" section=tt_hv5_5vnw
include "c018bcd_gen2_v1d6.scs" section=stat
include "c018bcd_gen2_v1d6.scs" section=stat_mim
include "c018bcd_gen2_v1d6.scs" section=stat_mom
include "c018bcd_gen2_v1d6.scs" section=stat_noise
include "c018bcd_gen2_v1d6.scs" section=stat_res
include "c018bcd_gen2_v1d6.scs" section=stat_res_hv
parOpt options redefinedparams=ignore
parameters mismatchflag_bip5_poly=0
parameters mismatchflag_bip5_rpo=0
parameters mismatchflag_bip=0
parameters mismatchflag_bip_hv=0
parameters mismatchflag_bip_rpo=0
parameters mismatchflag_cap5=0
parameters mismatchflag_disres=0
parameters mismatchflag_fmom=0
parameters mismatchflag_hv=0
parameters mismatchflag_mim=0
parameters mismatchflag_mos=0
parameters mismatchflag_mos_5=0
parameters mismatchflag_mos_5_fgd=0
parameters mismatchflag_mos_5_lvt=0
parameters mismatchflag_mos_5vna=0
parameters mismatchflag_mos_dep5=0
parameters mismatchflag_mos_na=0
parameters mismatchflag_res=0
parameters mismatchflag_res_hv=0
parameters mismatchflag_rtmom=0
endsection mc_lib

section mismatch_lib
include "c018bcd_gen2_v1d6.scs" section=tt
include "c018bcd_gen2_v1d6.scs" section=tt_5
include "c018bcd_gen2_v1d6.scs" section=tt_5_fgd
include "c018bcd_gen2_v1d6.scs" section=tt_5_lvt
include "c018bcd_gen2_v1d6.scs" section=tt_5_switch
include "c018bcd_gen2_v1d6.scs" section=tt_5vna
include "c018bcd_gen2_v1d6.scs" section=tt_bbmvar
include "c018bcd_gen2_v1d6.scs" section=tt_bbmvar5
include "c018bcd_gen2_v1d6.scs" section=tt_bip
include "c018bcd_gen2_v1d6.scs" section=tt_bip5_poly
include "c018bcd_gen2_v1d6.scs" section=tt_bip5_rpo
include "c018bcd_gen2_v1d6.scs" section=tt_bip_hv
include "c018bcd_gen2_v1d6.scs" section=tt_bip_rpo
include "c018bcd_gen2_v1d6.scs" section=tt_dep5
include "c018bcd_gen2_v1d6.scs" section=tt_dio
include "c018bcd_gen2_v1d6.scs" section=tt_dio_5
include "c018bcd_gen2_v1d6.scs" section=tt_dio_esd
include "c018bcd_gen2_v1d6.scs" section=tt_dio_hv
include "c018bcd_gen2_v1d6.scs" section=tt_dio_sbd_zd
include "c018bcd_gen2_v1d6.scs" section=tt_disres
include "c018bcd_gen2_v1d6.scs" section=tt_fmom
include "c018bcd_gen2_v1d6.scs" section=tt_hv
include "c018bcd_gen2_v1d6.scs" section=tt_hv5_5vnw
include "c018bcd_gen2_v1d6.scs" section=tt_mim
include "c018bcd_gen2_v1d6.scs" section=tt_na
include "c018bcd_gen2_v1d6.scs" section=tt_res
include "c018bcd_gen2_v1d6.scs" section=tt_res_hv
include "c018bcd_gen2_v1d6.scs" section=tt_rtmom
include "c018bcd_gen2_v1d6.scs" section=stat_mis
include "c018bcd_gen2_v1d6.scs" section=stat_mis_5
include "c018bcd_gen2_v1d6.scs" section=stat_mis_5_fgd
include "c018bcd_gen2_v1d6.scs" section=stat_mis_5_lvt
include "c018bcd_gen2_v1d6.scs" section=stat_mis_5vna
include "c018bcd_gen2_v1d6.scs" section=stat_mis_bbmvar5
include "c018bcd_gen2_v1d6.scs" section=stat_mis_bip
include "c018bcd_gen2_v1d6.scs" section=stat_mis_bip5_poly
include "c018bcd_gen2_v1d6.scs" section=stat_mis_bip5_rpo
include "c018bcd_gen2_v1d6.scs" section=stat_mis_bip_hv
include "c018bcd_gen2_v1d6.scs" section=stat_mis_bip_rpo
include "c018bcd_gen2_v1d6.scs" section=stat_mis_dep5
include "c018bcd_gen2_v1d6.scs" section=stat_mis_disres
include "c018bcd_gen2_v1d6.scs" section=stat_mis_fmom
include "c018bcd_gen2_v1d6.scs" section=stat_mis_hv
include "c018bcd_gen2_v1d6.scs" section=stat_mis_mim
include "c018bcd_gen2_v1d6.scs" section=stat_mis_na
include "c018bcd_gen2_v1d6.scs" section=stat_mis_res
include "c018bcd_gen2_v1d6.scs" section=stat_mis_res_hv
include "c018bcd_gen2_v1d6.scs" section=stat_mis_rtmom
include "c018bcd_gen2_v1d6.scs" section=stat_noise
parOpt options redefinedparams=ignore
parameters mismatchflag_bip5_poly=1
parameters mismatchflag_bip5_rpo=1
parameters mismatchflag_bip=1
parameters mismatchflag_bip_hv=1
parameters mismatchflag_bip_rpo=1
parameters mismatchflag_cap5=1
parameters mismatchflag_disres=1
parameters mismatchflag_fmom=1
parameters mismatchflag_hv=1
parameters mismatchflag_mim=1
parameters mismatchflag_mos=1
parameters mismatchflag_mos_5=1
parameters mismatchflag_mos_5_fgd=1
parameters mismatchflag_mos_5_lvt=1
parameters mismatchflag_mos_5vna=1
parameters mismatchflag_mos_dep5=1
parameters mismatchflag_mos_na=1
parameters mismatchflag_res=1
parameters mismatchflag_res_hv=1
parameters mismatchflag_rtmom=1
endsection mismatch_lib
