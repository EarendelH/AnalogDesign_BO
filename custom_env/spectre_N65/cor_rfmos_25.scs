library rfmos_25_cor

section ff_rfmos_25
include "crn65gplus_2d5_lk_v1d0.scs" section = ff_rfmos_25
endsection ff_rfmos_25

section fs_rfmos_25
include "crn65gplus_2d5_lk_v1d0.scs" section = fs_rfmos_25
endsection fs_rfmos_25

section sf_rfmos_25
include "crn65gplus_2d5_lk_v1d0.scs" section = sf_rfmos_25
endsection sf_rfmos_25

section ss_rfmos_25
include "crn65gplus_2d5_lk_v1d0.scs" section = ss_rfmos_25
endsection ss_rfmos_25

section tt_rfmos_25
include "crn65gplus_2d5_lk_v1d0.scs" section = tt_rfmos_25
endsection tt_rfmos_25

endlibrary rfmos_25_cor
