library rfmvar_cor

section ff_rfmvar
include "crn65gplus_2d5_lk_v1d0.scs" section = ff_rfmvar
endsection ff_rfmvar

section ss_rfmvar
include "crn65gplus_2d5_lk_v1d0.scs" section = ss_rfmvar
endsection ss_rfmvar

section tt_rfmvar
include "crn65gplus_2d5_lk_v1d0.scs" section = tt_rfmvar
endsection tt_rfmvar

endlibrary rfmvar_cor
