library hvt_cor

section ff_hvt
include "crn65gplus_2d5_lk_v1d0.scs" section = ff_hvt
endsection ff_hvt

section fs_hvt
include "crn65gplus_2d5_lk_v1d0.scs" section = fs_hvt
endsection fs_hvt

section sf_hvt
include "crn65gplus_2d5_lk_v1d0.scs" section = sf_hvt
endsection sf_hvt

section ss_hvt
include "crn65gplus_2d5_lk_v1d0.scs" section = ss_hvt
endsection ss_hvt

section tt_hvt
include "crn65gplus_2d5_lk_v1d0.scs" section = tt_hvt
endsection tt_hvt

endlibrary hvt_cor
