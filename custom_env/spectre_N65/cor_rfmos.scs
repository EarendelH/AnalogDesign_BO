library rfmos_cor

section ff_rfmos
include "crn65gplus_2d5_lk_v1d0.scs" section = ff_rfmos
endsection ff_rfmos

section fs_rfmos
include "crn65gplus_2d5_lk_v1d0.scs" section = fs_rfmos
endsection fs_rfmos

section sf_rfmos
include "crn65gplus_2d5_lk_v1d0.scs" section = sf_rfmos
endsection sf_rfmos

section ss_rfmos
include "crn65gplus_2d5_lk_v1d0.scs" section = ss_rfmos
endsection ss_rfmos

section tt_rfmos
include "crn65gplus_2d5_lk_v1d0.scs" section = tt_rfmos
endsection tt_rfmos

endlibrary rfmos_cor
