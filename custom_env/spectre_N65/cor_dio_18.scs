library dio_18_cor

section ff_dio_18
include "crn65gplus_2d5_lk_v1d0.scs" section = ff_dio_18
endsection ff_dio_18

section ss_dio_18
include "crn65gplus_2d5_lk_v1d0.scs" section = ss_dio_18
endsection ss_dio_18

section tt_dio_18
include "crn65gplus_2d5_lk_v1d0.scs" section = tt_dio_18
endsection tt_dio_18

endlibrary dio_18_cor
