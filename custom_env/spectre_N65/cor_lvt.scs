library lvt_cor

section ff_lvt
include "crn65gplus_2d5_lk_v1d0.scs" section = ff_lvt
endsection ff_lvt

section fs_lvt
include "crn65gplus_2d5_lk_v1d0.scs" section = fs_lvt
endsection fs_lvt

section sf_lvt
include "crn65gplus_2d5_lk_v1d0.scs" section = sf_lvt
endsection sf_lvt

section ss_lvt
include "crn65gplus_2d5_lk_v1d0.scs" section = ss_lvt
endsection ss_lvt

section tt_lvt
include "crn65gplus_2d5_lk_v1d0.scs" section = tt_lvt
endsection tt_lvt

endlibrary lvt_cor
