library dio_lvt_cor

section ff_dio_lvt
include "crn65gplus_2d5_lk_v1d0.scs" section = ff_dio_lvt
endsection ff_dio_lvt

section ss_dio_lvt
include "crn65gplus_2d5_lk_v1d0.scs" section = ss_dio_lvt
endsection ss_dio_lvt

section tt_dio_lvt
include "crn65gplus_2d5_lk_v1d0.scs" section = tt_dio_lvt
endsection tt_dio_lvt

endlibrary dio_lvt_cor
