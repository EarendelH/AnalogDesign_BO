library bip_npn_cor

section ff_bip_npn
include "crn65gplus_2d5_lk_v1d0.scs" section = ff_bip_npn
endsection ff_bip_npn

section ss_bip_npn
include "crn65gplus_2d5_lk_v1d0.scs" section = ss_bip_npn
endsection ss_bip_npn

section tt_bip_npn
include "crn65gplus_2d5_lk_v1d0.scs" section = tt_bip_npn
endsection tt_bip_npn

endlibrary bip_npn_cor
