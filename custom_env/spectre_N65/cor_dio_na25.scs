library dio_na25_cor

section ff_dio_na25
include "crn65gplus_2d5_lk_v1d0.scs" section = ff_dio_na25
endsection ff_dio_na25

section ss_dio_na25
include "crn65gplus_2d5_lk_v1d0.scs" section = ss_dio_na25
endsection ss_dio_na25

section tt_dio_na25
include "crn65gplus_2d5_lk_v1d0.scs" section = tt_dio_na25
endsection tt_dio_na25

endlibrary dio_na25_cor
