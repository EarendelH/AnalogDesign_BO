library rfmos_33_cor

section ff_rfmos_33
include "crn65gplus_2d5_lk_v1d0.scs" section = ff_rfmos_33
endsection ff_rfmos_33

section fs_rfmos_33
include "crn65gplus_2d5_lk_v1d0.scs" section = fs_rfmos_33
endsection fs_rfmos_33

section sf_rfmos_33
include "crn65gplus_2d5_lk_v1d0.scs" section = sf_rfmos_33
endsection sf_rfmos_33

section ss_rfmos_33
include "crn65gplus_2d5_lk_v1d0.scs" section = ss_rfmos_33
endsection ss_rfmos_33

section tt_rfmos_33
include "crn65gplus_2d5_lk_v1d0.scs" section = tt_rfmos_33
endsection tt_rfmos_33

endlibrary rfmos_33_cor
