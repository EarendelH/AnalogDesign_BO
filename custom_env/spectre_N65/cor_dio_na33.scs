library dio_na33_cor

section ff_dio_na33
include "crn65gplus_2d5_lk_v1d0.scs" section = ff_dio_na33
endsection ff_dio_na33

section ss_dio_na33
include "crn65gplus_2d5_lk_v1d0.scs" section = ss_dio_na33
endsection ss_dio_na33

section tt_dio_na33
include "crn65gplus_2d5_lk_v1d0.scs" section = tt_dio_na33
endsection tt_dio_na33

endlibrary dio_na33_cor
