library 18_cor

section ff_18
include "crn65gplus_2d5_lk_v1d0.scs" section = ff_18
endsection ff_18

section fs_18
include "crn65gplus_2d5_lk_v1d0.scs" section = fs_18
endsection fs_18

section sf_18
include "crn65gplus_2d5_lk_v1d0.scs" section = sf_18
endsection sf_18

section ss_18
include "crn65gplus_2d5_lk_v1d0.scs" section = ss_18
endsection ss_18

section tt_18
include "crn65gplus_2d5_lk_v1d0.scs" section = tt_18
endsection tt_18

endlibrary 18_cor
