library rfmos_18_cor

section ff_rfmos_18
include "crn65gplus_2d5_lk_v1d0.scs" section = ff_rfmos_18
endsection ff_rfmos_18

section fs_rfmos_18
include "crn65gplus_2d5_lk_v1d0.scs" section = fs_rfmos_18
endsection fs_rfmos_18

section sf_rfmos_18
include "crn65gplus_2d5_lk_v1d0.scs" section = sf_rfmos_18
endsection sf_rfmos_18

section ss_rfmos_18
include "crn65gplus_2d5_lk_v1d0.scs" section = ss_rfmos_18
endsection ss_rfmos_18

section tt_rfmos_18
include "crn65gplus_2d5_lk_v1d0.scs" section = tt_rfmos_18
endsection tt_rfmos_18

endlibrary rfmos_18_cor
