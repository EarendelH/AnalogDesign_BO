library mos_cap_cor

section ff_mos_cap
include "crn65gplus_2d5_lk_v1d0.scs" section = ff_mos_cap
endsection ff_mos_cap

section ss_mos_cap
include "crn65gplus_2d5_lk_v1d0.scs" section = ss_mos_cap
endsection ss_mos_cap

section tt_mos_cap
include "crn65gplus_2d5_lk_v1d0.scs" section = tt_mos_cap
endsection tt_mos_cap

endlibrary mos_cap_cor
