library std_mos_cor

section ff
include "crn65gplus_2d5_lk_v1d0.scs" section = ff
endsection ff

section fs
include "crn65gplus_2d5_lk_v1d0.scs" section = fs
endsection fs

section sf
include "crn65gplus_2d5_lk_v1d0.scs" section = sf
endsection sf

section ss
include "crn65gplus_2d5_lk_v1d0.scs" section = ss
endsection ss

section tt
include "crn65gplus_2d5_lk_v1d0.scs" section = tt
endsection tt

endlibrary std_mos_cor
