library 25od33_cor

section ff_25od33
include "crn65gplus_2d5_lk_v1d0.scs" section = ff_25od33
endsection ff_25od33

section fs_25od33
include "crn65gplus_2d5_lk_v1d0.scs" section = fs_25od33
endsection fs_25od33

section sf_25od33
include "crn65gplus_2d5_lk_v1d0.scs" section = sf_25od33
endsection sf_25od33

section ss_25od33
include "crn65gplus_2d5_lk_v1d0.scs" section = ss_25od33
endsection ss_25od33

section tt_25od33
include "crn65gplus_2d5_lk_v1d0.scs" section = tt_25od33
endsection tt_25od33

endlibrary 25od33_cor
