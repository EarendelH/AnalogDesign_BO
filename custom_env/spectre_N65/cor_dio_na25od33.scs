library dio_na25od33_cor

section ff_dio_na25od33
include "crn65gplus_2d5_lk_v1d0.scs" section = ff_dio_na25od33
endsection ff_dio_na25od33

section ss_dio_na25od33
include "crn65gplus_2d5_lk_v1d0.scs" section = ss_dio_na25od33
endsection ss_dio_na25od33

section tt_dio_na25od33
include "crn65gplus_2d5_lk_v1d0.scs" section = tt_dio_na25od33
endsection tt_dio_na25od33

endlibrary dio_na25od33_cor
