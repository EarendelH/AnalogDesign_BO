library na25_cor

section ff_na25
include "crn65gplus_2d5_lk_v1d0.scs" section = ff_na25
endsection ff_na25

section fs_na25
include "crn65gplus_2d5_lk_v1d0.scs" section = fs_na25
endsection fs_na25

section sf_na25
include "crn65gplus_2d5_lk_v1d0.scs" section = sf_na25
endsection sf_na25

section ss_na25
include "crn65gplus_2d5_lk_v1d0.scs" section = ss_na25
endsection ss_na25

section tt_na25
include "crn65gplus_2d5_lk_v1d0.scs" section = tt_na25
endsection tt_na25

endlibrary na25_cor
