library rfind_cor

section ff_rfind
include "crn65gplus_2d5_lk_v1d0.scs" section = ff_rfind
endsection ff_rfind

section ss_rfind
include "crn65gplus_2d5_lk_v1d0.scs" section = ss_rfind
endsection ss_rfind

section tt_rfind
include "crn65gplus_2d5_lk_v1d0.scs" section = tt_rfind
endsection tt_rfind

endlibrary rfind_cor
