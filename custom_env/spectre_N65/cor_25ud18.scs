library 25ud18_cor

section ff_25ud18
include "crn65gplus_2d5_lk_v1d0.scs" section = ff_25ud18
endsection ff_25ud18

section fs_25ud18
include "crn65gplus_2d5_lk_v1d0.scs" section = fs_25ud18
endsection fs_25ud18

section sf_25ud18
include "crn65gplus_2d5_lk_v1d0.scs" section = sf_25ud18
endsection sf_25ud18

section ss_25ud18
include "crn65gplus_2d5_lk_v1d0.scs" section = ss_25ud18
endsection ss_25ud18

section tt_25ud18
include "crn65gplus_2d5_lk_v1d0.scs" section = tt_25ud18
endsection tt_25ud18

endlibrary 25ud18_cor
