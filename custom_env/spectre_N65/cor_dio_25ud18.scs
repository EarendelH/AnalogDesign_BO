library dio_25ud18_cor

section ff_dio_25ud18
include "crn65gplus_2d5_lk_v1d0.scs" section = ff_dio_25ud18
endsection ff_dio_25ud18

section ss_dio_25ud18
include "crn65gplus_2d5_lk_v1d0.scs" section = ss_dio_25ud18
endsection ss_dio_25ud18

section tt_dio_25ud18
include "crn65gplus_2d5_lk_v1d0.scs" section = tt_dio_25ud18
endsection tt_dio_25ud18

endlibrary dio_25ud18_cor
