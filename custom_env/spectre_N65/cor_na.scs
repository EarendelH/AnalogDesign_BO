library na_cor

section ff_na
include "crn65gplus_2d5_lk_v1d0.scs" section = ff_na
endsection ff_na

section fs_na
include "crn65gplus_2d5_lk_v1d0.scs" section = fs_na
endsection fs_na

section sf_na
include "crn65gplus_2d5_lk_v1d0.scs" section = sf_na
endsection sf_na

section ss_na
include "crn65gplus_2d5_lk_v1d0.scs" section = ss_na
endsection ss_na

section tt_na
include "crn65gplus_2d5_lk_v1d0.scs" section = tt_na
endsection tt_na

endlibrary na_cor
