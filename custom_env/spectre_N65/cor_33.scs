library 33_cor

section ff_33
include "crn65gplus_2d5_lk_v1d0.scs" section = ff_33
endsection ff_33

section fs_33
include "crn65gplus_2d5_lk_v1d0.scs" section = fs_33
endsection fs_33

section sf_33
include "crn65gplus_2d5_lk_v1d0.scs" section = sf_33
endsection sf_33

section ss_33
include "crn65gplus_2d5_lk_v1d0.scs" section = ss_33
endsection ss_33

section tt_33
include "crn65gplus_2d5_lk_v1d0.scs" section = tt_33
endsection tt_33

endlibrary 33_cor
