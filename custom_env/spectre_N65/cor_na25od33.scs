library na25od33_cor

section ff_na25od33
include "crn65gplus_2d5_lk_v1d0.scs" section = ff_na25od33
endsection ff_na25od33

section fs_na25od33
include "crn65gplus_2d5_lk_v1d0.scs" section = fs_na25od33
endsection fs_na25od33

section sf_na25od33
include "crn65gplus_2d5_lk_v1d0.scs" section = sf_na25od33
endsection sf_na25od33

section ss_na25od33
include "crn65gplus_2d5_lk_v1d0.scs" section = ss_na25od33
endsection ss_na25od33

section tt_na25od33
include "crn65gplus_2d5_lk_v1d0.scs" section = tt_na25od33
endsection tt_na25od33

endlibrary na25od33_cor
