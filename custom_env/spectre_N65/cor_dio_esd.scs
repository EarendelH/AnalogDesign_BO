library dio_esd_cor

section ff_dio_esd
include "crn65gplus_2d5_lk_v1d0.scs" section = ff_dio_esd
endsection ff_dio_esd

section ss_dio_esd
include "crn65gplus_2d5_lk_v1d0.scs" section = ss_dio_esd
endsection ss_dio_esd

section tt_dio_esd
include "crn65gplus_2d5_lk_v1d0.scs" section = tt_dio_esd
endsection tt_dio_esd

endlibrary dio_esd_cor
