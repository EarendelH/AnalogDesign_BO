library rfres_sa_cor

section ff_rfres_sa
include "crn65gplus_2d5_lk_v1d0.scs" section = ff_rfres_sa
endsection ff_rfres_sa

section ss_rfres_sa
include "crn65gplus_2d5_lk_v1d0.scs" section = ss_rfres_sa
endsection ss_rfres_sa

section tt_rfres_sa
include "crn65gplus_2d5_lk_v1d0.scs" section = tt_rfres_sa
endsection tt_rfres_sa

endlibrary rfres_sa_cor
