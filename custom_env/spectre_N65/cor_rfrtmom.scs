library rfrtmom_cor

section ff_rfrtmom
include "crn65gplus_2d5_lk_v1d0.scs" section = ff_rfrtmom
endsection ff_rfrtmom

section ss_rfrtmom
include "crn65gplus_2d5_lk_v1d0.scs" section = ss_rfrtmom
endsection ss_rfrtmom

section tt_rfrtmom
include "crn65gplus_2d5_lk_v1d0.scs" section = tt_rfrtmom
endsection tt_rfrtmom

endlibrary rfrtmom_cor
