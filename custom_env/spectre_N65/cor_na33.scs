library na33_cor

section ff_na33
include "crn65gplus_2d5_lk_v1d0.scs" section = ff_na33
endsection ff_na33

section fs_na33
include "crn65gplus_2d5_lk_v1d0.scs" section = fs_na33
endsection fs_na33

section sf_na33
include "crn65gplus_2d5_lk_v1d0.scs" section = sf_na33
endsection sf_na33

section ss_na33
include "crn65gplus_2d5_lk_v1d0.scs" section = ss_na33
endsection ss_na33

section tt_na33
include "crn65gplus_2d5_lk_v1d0.scs" section = tt_na33
endsection tt_na33

endlibrary na33_cor
