library dio_33_cor

section ff_dio_33
include "crn65gplus_2d5_lk_v1d0.scs" section = ff_dio_33
endsection ff_dio_33

section ss_dio_33
include "crn65gplus_2d5_lk_v1d0.scs" section = ss_dio_33
endsection ss_dio_33

section tt_dio_33
include "crn65gplus_2d5_lk_v1d0.scs" section = tt_dio_33
endsection tt_dio_33

endlibrary dio_33_cor
