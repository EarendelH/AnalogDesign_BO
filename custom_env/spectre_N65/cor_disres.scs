library disres_cor

section ff_disres
include "crn65gplus_2d5_lk_v1d0.scs" section = ff_disres
endsection ff_disres

section ss_disres
include "crn65gplus_2d5_lk_v1d0.scs" section = ss_disres
endsection ss_disres

section tt_disres
include "crn65gplus_2d5_lk_v1d0.scs" section = tt_disres
endsection tt_disres

endlibrary disres_cor
