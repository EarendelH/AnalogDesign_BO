// Design: LDO_JSSC2010_Jianping_N65/tb_Trans_0_75V
simulator lang=spectre
global 0
parameters C1=1p C2=1p CM=1p IB=1u R1=10k
include "/data/PDK/pdk_installed/tsmc65_gp/tsmcN65/../models/spectre/crn65gplus_2d5_lk_v1d0.scs" section=tt_bip
include "/data/PDK/pdk_installed/tsmc65_gp/tsmcN65/../models/spectre/crn65gplus_2d5_lk_v1d0.scs" section=tt_dio
include "/data/PDK/pdk_installed/tsmc65_gp/tsmcN65/../models/spectre/crn65gplus_2d5_lk_v1d0.scs" section=tt_dio_33
include "/data/PDK/pdk_installed/tsmc65_gp/tsmcN65/../models/spectre/crn65gplus_2d5_lk_v1d0.scs" section=tt_mim
include "/data/PDK/pdk_installed/tsmc65_gp/tsmcN65/../models/spectre/crn65gplus_2d5_lk_v1d0.scs" section=tt_dio_dnw
include "/data/PDK/pdk_installed/tsmc65_gp/tsmcN65/../models/spectre/crn65gplus_2d5_lk_v1d0.scs" section=tt_dio_18
include "/data/PDK/pdk_installed/tsmc65_gp/tsmcN65/../models/spectre/crn65gplus_2d5_lk_v1d0.scs" section=tt_bip_npn
include "/data/PDK/pdk_installed/tsmc65_gp/tsmcN65/../models/spectre/crn65gplus_2d5_lk_v1d0.scs" section=tt_33
include "/data/PDK/pdk_installed/tsmc65_gp/tsmcN65/../models/spectre/crn65gplus_2d5_lk_v1d0.scs" section=tt_rfrtmom
include "/data/PDK/pdk_installed/tsmc65_gp/tsmcN65/../models/spectre/crn65gplus_2d5_lk_v1d0.scs" section=tt_mos_cap_25
include "/data/PDK/pdk_installed/tsmc65_gp/tsmcN65/../models/spectre/crn65gplus_2d5_lk_v1d0.scs" section=tt_18
include "/data/PDK/pdk_installed/tsmc65_gp/tsmcN65/../models/spectre/crn65gplus_2d5_lk_v1d0.scs" section=tt_disres
include "/data/PDK/pdk_installed/tsmc65_gp/tsmcN65/../models/spectre/crn65gplus_2d5_lk_v1d0.scs" section=tt_res
include "/data/PDK/pdk_installed/tsmc65_gp/tsmcN65/../models/spectre/crn65gplus_2d5_lk_v1d0.scs" section=tt_dio_na
include "/data/PDK/pdk_installed/tsmc65_gp/tsmcN65/../models/spectre/crn65gplus_2d5_lk_v1d0.scs" section=tt_rfmos_33
include "/data/PDK/pdk_installed/tsmc65_gp/tsmcN65/../models/spectre/crn65gplus_2d5_lk_v1d0.scs" section=tt_dio_hvt
include "/data/PDK/pdk_installed/tsmc65_gp/tsmcN65/../models/spectre/crn65gplus_2d5_lk_v1d0.scs" section=tt_rfmvar
include "/data/PDK/pdk_installed/tsmc65_gp/tsmcN65/../models/spectre/crn65gplus_2d5_lk_v1d0.scs" section=tt_rfmos_18
include "/data/PDK/pdk_installed/tsmc65_gp/tsmcN65/../models/spectre/crn65gplus_2d5_lk_v1d0.scs" section=tt_na
include "/data/PDK/pdk_installed/tsmc65_gp/tsmcN65/../models/spectre/crn65gplus_2d5_lk_v1d0.scs" section=tt_dio_na33
include "/data/PDK/pdk_installed/tsmc65_gp/tsmcN65/../models/spectre/crn65gplus_2d5_lk_v1d0.scs" section=tt_dio_lvt
include "/data/PDK/pdk_installed/tsmc65_gp/tsmcN65/../models/spectre/crn65gplus_2d5_lk_v1d0.scs" section=tt_rfres_sa
include "/data/PDK/pdk_installed/tsmc65_gp/tsmcN65/../models/spectre/crn65gplus_2d5_lk_v1d0.scs" section=tt_na33
include "/data/PDK/pdk_installed/tsmc65_gp/tsmcN65/../models/spectre/crn65gplus_2d5_lk_v1d0.scs" section=tt_dio_esd
include "/data/PDK/pdk_installed/tsmc65_gp/tsmcN65/../models/spectre/crn65gplus_2d5_lk_v1d0.scs" section=tt_rfmim
include "/data/PDK/pdk_installed/tsmc65_gp/tsmcN65/../models/spectre/crn65gplus_2d5_lk_v1d0.scs" section=tt_dio_25od33
include "/data/PDK/pdk_installed/tsmc65_gp/tsmcN65/../models/spectre/crn65gplus_2d5_lk_v1d0.scs" section=tt_25od33
include "/data/PDK/pdk_installed/tsmc65_gp/tsmcN65/../models/spectre/crn65gplus_2d5_lk_v1d0.scs" section=tt
include "/data/PDK/pdk_installed/tsmc65_gp/tsmcN65/../models/spectre/crn65gplus_2d5_lk_v1d0.scs" section=tt_mos_cap
include "/data/PDK/pdk_installed/tsmc65_gp/tsmcN65/../models/spectre/crn65gplus_2d5_lk_v1d0.scs" section=tt_dio_25
include "/data/PDK/pdk_installed/tsmc65_gp/tsmcN65/../models/spectre/crn65gplus_2d5_lk_v1d0.scs" section=tt_dio_25ud18
include "/data/PDK/pdk_installed/tsmc65_gp/tsmcN65/../models/spectre/crn65gplus_2d5_lk_v1d0.scs" section=tt_25
include "/data/PDK/pdk_installed/tsmc65_gp/tsmcN65/../models/spectre/crn65gplus_2d5_lk_v1d0.scs" section=tt_rfmos
include "/data/PDK/pdk_installed/tsmc65_gp/tsmcN65/../models/spectre/crn65gplus_2d5_lk_v1d0.scs" section=tt_25ud18
include "/data/PDK/pdk_installed/tsmc65_gp/tsmcN65/../models/spectre/crn65gplus_2d5_lk_v1d0.scs" section=tt_dio_na25od33
include "/data/PDK/pdk_installed/tsmc65_gp/tsmcN65/../models/spectre/crn65gplus_2d5_lk_v1d0.scs" section=tt_rfjvar
include "/data/PDK/pdk_installed/tsmc65_gp/tsmcN65/../models/spectre/crn65gplus_2d5_lk_v1d0.scs" section=tt_rfmos_25
include "/data/PDK/pdk_installed/tsmc65_gp/tsmcN65/../models/spectre/crn65gplus_2d5_lk_v1d0.scs" section=tt_rtmom
include "/data/PDK/pdk_installed/tsmc65_gp/tsmcN65/../models/spectre/crn65gplus_2d5_lk_v1d0.scs" section=tt_na25od33
include "/data/PDK/pdk_installed/tsmc65_gp/tsmcN65/../models/spectre/crn65gplus_2d5_lk_v1d0.scs" section=tt_dio_na25
include "/data/PDK/pdk_installed/tsmc65_gp/tsmcN65/../models/spectre/crn65gplus_2d5_lk_v1d0.scs" section=tt_rfres_rpo
include "/data/PDK/pdk_installed/tsmc65_gp/tsmcN65/../models/spectre/crn65gplus_2d5_lk_v1d0.scs" section=tt_hvt
include "/data/PDK/pdk_installed/tsmc65_gp/tsmcN65/../models/spectre/crn65gplus_2d5_lk_v1d0.scs" section=tt_rfind
include "/data/PDK/pdk_installed/tsmc65_gp/tsmcN65/../models/spectre/crn65gplus_2d5_lk_v1d0.scs" section=tt_rfmvar_25
include "/data/PDK/pdk_installed/tsmc65_gp/tsmcN65/../models/spectre/crn65gplus_2d5_lk_v1d0.scs" section=tt_na25
include "/data/PDK/pdk_installed/tsmc65_gp/tsmcN65/../models/spectre/crn65gplus_2d5_lk_v1d0.scs" section=tt_lvt

// LDO_JSSC2010_Jianping_N65/LDO_Core/schematic
subckt LDO_Core VFB VIN VOUT VREF VSS
    M16 (net20 net16 VIN VIN) pch_mac l=60n w=200n multi=1 nf=1 sigma=1 mismatchflag=1
    M21 (net22 net20 VIN VIN) pch_mac l=60n w=200n multi=1 nf=1 sigma=1 mismatchflag=1
    M24 (net26 net16 VIN VIN) pch_mac l=60n w=200n multi=1 nf=1 sigma=1 mismatchflag=1
    M12 (net32 net32 net35 VDD) pch_mac l=60n w=200n multi=1 nf=1 sigma=1 mismatchflag=1
    M11 (net45 net32 VFB VDD) pch_mac l=60n w=200n multi=1 nf=1 sigma=1 mismatchflag=1
    M5 (net35 net37 VIN VIN) pch_mac l=60n w=200n multi=1 nf=1 sigma=1 mismatchflag=1
    M4 (net42 net42 VIN VIN) pch_mac l=60n w=200n multi=1 nf=1 sigma=1 mismatchflag=1
    M3 (net37 net42 VIN VIN) pch_mac l=60n w=200n multi=1 nf=1 sigma=1 mismatchflag=1
    C1 (VFB net9) capacitor c=C1
    C3 (net20 VFB) capacitor c=CM
    C2 (net37 VSS) capacitor c=C2
    R1 (net8 net9) resistor r=R1
    I0 (VIN net8) isource dc=IB type=dc
    M33 (net16 net16 VIN VIN) pch_mac l=60n w=200n multi=1 nf=1 sigma=1 mismatchflag=1
    M0 (VOUT net26 VIN VIN) pch_mac l=500n w=50u multi=1 nf=1 sigma=1 mismatchflag=1
    M31 (net8 net8 VSS VSS) nch_mac l=60n w=200n multi=1 nf=1 sigma=1 mismatchflag=1
    M32 (net16 net9 VSS VSS) nch_mac l=60n w=200n multi=1 nf=1 sigma=1 mismatchflag=1
    M15 (net20 VREF net45 VSS) nch_mac l=60n w=200n multi=1 nf=1 sigma=1 mismatchflag=1
    M22 (net22 net22 VSS VSS) nch_mac l=60n w=200n multi=1 nf=1 sigma=1 mismatchflag=1
    M23 (net26 net22 VSS VSS) nch_mac l=60n w=200n multi=1 nf=1 sigma=1 mismatchflag=1
    M14 (net32 net8 VSS VSS) nch_mac l=60n w=200n multi=1 nf=1 sigma=1 mismatchflag=1
    M13 (net45 net8 VSS VSS) nch_mac l=60n w=200n multi=1 nf=1 sigma=1 mismatchflag=1
    M6 (net41 net8 VSS VSS) nch_mac l=60n w=200n multi=1 nf=1 sigma=1 mismatchflag=1
    M2 (net37 VREF net41 VSS) nch_mac l=60n w=200n multi=1 nf=1 sigma=1 mismatchflag=1
    M1 (net42 net35 net41 VSS) nch_mac l=60n w=200n multi=1 nf=1 sigma=1 mismatchflag=1
ends LDO_Core

// LDO_JSSC2010_Jianping_N65/tb_Trans_0_75V/schematic
V2 (VIN 0) vsource dc=750.00m type=dc
V1 (VREF 0) vsource dc=500.0m type=dc
V0 (VSS 0) vsource dc=0 type=dc
I1 (VOUT VSS) isource type=pulse val0=1.5m val1=100m period=10u delay=5u rise=100n fall=100n width=5u
C0 (VOUT VSS) capacitor c=50p
I0 (VOUT VIN VOUT VREF VSS) LDO_Core
simulatorOptions options temp=27
tran tran stop=15u errpreset=conservative
