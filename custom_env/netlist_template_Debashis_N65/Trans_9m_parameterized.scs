// Design: LDO_TCASII_Debashis_N65/tb_Trans_9m
simulator lang=spectre
global 0
parameters VB1 VB2 VB3 CC RC w_M30_per_finger l_M30 nf_M30 w_M60_per_finger l_M60 nf_M60 w_M64_per_finger l_M64 nf_M64 w_M6_per_finger l_M6 nf_M6 w_M5_per_finger l_M5 nf_M5 w_M24_per_finger l_M24 nf_M24 w_M23_per_finger l_M23 nf_M23 w_M63_per_finger l_M63 nf_M63 w_M62_per_finger l_M62 nf_M62 w_M61_per_finger l_M61 nf_M61 w_M21_per_finger l_M21 nf_M21 w_M22_per_finger l_M22 nf_M22 w_M0_per_finger l_M0 nf_M0 w_M11_per_finger l_M11 nf_M11 w_M12_per_finger l_M12 nf_M12 w_M10_per_finger l_M10 nf_M10 w_M9_per_finger l_M9 nf_M9 w_M7_per_finger l_M7 nf_M7 w_M8_per_finger l_M8 nf_M8 w_M42_per_finger l_M42 nf_M42 w_M41_per_finger l_M41 nf_M41 w_M2_per_finger l_M2 nf_M2 w_M1_per_finger l_M1 nf_M1
include "/data/PDK/pdk_installed/tsmc65_gp/tsmcN65/../models/spectre/crn65gplus_2d5_lk_v1d0.scs" section=tt_bip
include "/data/PDK/pdk_installed/tsmc65_gp/tsmcN65/../models/spectre/crn65gplus_2d5_lk_v1d0.scs" section=tt_dio
include "/data/PDK/pdk_installed/tsmc65_gp/tsmcN65/../models/spectre/crn65gplus_2d5_lk_v1d0.scs" section=tt_dio_33
include "/data/PDK/pdk_installed/tsmc65_gp/tsmcN65/../models/spectre/crn65gplus_2d5_lk_v1d0.scs" section=tt_mim
include "/data/PDK/pdk_installed/tsmc65_gp/tsmcN65/../models/spectre/crn65gplus_2d5_lk_v1d0.scs" section=tt_dio_dnw
include "/data/PDK/pdk_installed/tsmc65_gp/tsmcN65/../models/spectre/crn65gplus_2d5_lk_v1d0.scs" section=tt_dio_18
include "/data/PDK/pdk_installed/tsmc65_gp/tsmcN65/../models/spectre/crn65gplus_2d5_lk_v1d0.scs" section=tt_bip_npn
include "/data/PDK/pdk_installed/tsmc65_gp/tsmcN65/../models/spectre/crn65gplus_2d5_lk_v1d0.scs" section=tt_33
include "/data/PDK/pdk_installed/tsmc65_gp/tsmcN65/../models/spectre/crn65gplus_2d5_lk_v1d0.scs" section=tt_rfrtmom
include "/data/PDK/pdk_installed/tsmc65_gp/tsmcN65/../models/spectre/crn65gplus_2d5_lk_v1d0.scs" section=tt_mos_cap_25
include "/data/PDK/pdk_installed/tsmc65_gp/tsmcN65/../models/spectre/crn65gplus_2d5_lk_v1d0.scs" section=tt_18
include "/data/PDK/pdk_installed/tsmc65_gp/tsmcN65/../models/spectre/crn65gplus_2d5_lk_v1d0.scs" section=tt_disres
include "/data/PDK/pdk_installed/tsmc65_gp/tsmcN65/../models/spectre/crn65gplus_2d5_lk_v1d0.scs" section=tt_res
include "/data/PDK/pdk_installed/tsmc65_gp/tsmcN65/../models/spectre/crn65gplus_2d5_lk_v1d0.scs" section=tt_dio_na
include "/data/PDK/pdk_installed/tsmc65_gp/tsmcN65/../models/spectre/crn65gplus_2d5_lk_v1d0.scs" section=tt_rfmos_33
include "/data/PDK/pdk_installed/tsmc65_gp/tsmcN65/../models/spectre/crn65gplus_2d5_lk_v1d0.scs" section=tt_dio_hvt
include "/data/PDK/pdk_installed/tsmc65_gp/tsmcN65/../models/spectre/crn65gplus_2d5_lk_v1d0.scs" section=tt_rfmvar
include "/data/PDK/pdk_installed/tsmc65_gp/tsmcN65/../models/spectre/crn65gplus_2d5_lk_v1d0.scs" section=tt_rfmos_18
include "/data/PDK/pdk_installed/tsmc65_gp/tsmcN65/../models/spectre/crn65gplus_2d5_lk_v1d0.scs" section=tt_na
include "/data/PDK/pdk_installed/tsmc65_gp/tsmcN65/../models/spectre/crn65gplus_2d5_lk_v1d0.scs" section=tt_dio_na33
include "/data/PDK/pdk_installed/tsmc65_gp/tsmcN65/../models/spectre/crn65gplus_2d5_lk_v1d0.scs" section=tt_dio_lvt
include "/data/PDK/pdk_installed/tsmc65_gp/tsmcN65/../models/spectre/crn65gplus_2d5_lk_v1d0.scs" section=tt_rfres_sa
include "/data/PDK/pdk_installed/tsmc65_gp/tsmcN65/../models/spectre/crn65gplus_2d5_lk_v1d0.scs" section=tt_na33
include "/data/PDK/pdk_installed/tsmc65_gp/tsmcN65/../models/spectre/crn65gplus_2d5_lk_v1d0.scs" section=tt_dio_esd
include "/data/PDK/pdk_installed/tsmc65_gp/tsmcN65/../models/spectre/crn65gplus_2d5_lk_v1d0.scs" section=tt_rfmim
include "/data/PDK/pdk_installed/tsmc65_gp/tsmcN65/../models/spectre/crn65gplus_2d5_lk_v1d0.scs" section=tt_dio_25od33
include "/data/PDK/pdk_installed/tsmc65_gp/tsmcN65/../models/spectre/crn65gplus_2d5_lk_v1d0.scs" section=tt_25od33
include "/data/PDK/pdk_installed/tsmc65_gp/tsmcN65/../models/spectre/crn65gplus_2d5_lk_v1d0.scs" section=tt
include "/data/PDK/pdk_installed/tsmc65_gp/tsmcN65/../models/spectre/crn65gplus_2d5_lk_v1d0.scs" section=tt_mos_cap
include "/data/PDK/pdk_installed/tsmc65_gp/tsmcN65/../models/spectre/crn65gplus_2d5_lk_v1d0.scs" section=tt_dio_25
include "/data/PDK/pdk_installed/tsmc65_gp/tsmcN65/../models/spectre/crn65gplus_2d5_lk_v1d0.scs" section=tt_dio_25ud18
include "/data/PDK/pdk_installed/tsmc65_gp/tsmcN65/../models/spectre/crn65gplus_2d5_lk_v1d0.scs" section=tt_25
include "/data/PDK/pdk_installed/tsmc65_gp/tsmcN65/../models/spectre/crn65gplus_2d5_lk_v1d0.scs" section=tt_rfmos
include "/data/PDK/pdk_installed/tsmc65_gp/tsmcN65/../models/spectre/crn65gplus_2d5_lk_v1d0.scs" section=tt_25ud18
include "/data/PDK/pdk_installed/tsmc65_gp/tsmcN65/../models/spectre/crn65gplus_2d5_lk_v1d0.scs" section=tt_dio_na25od33
include "/data/PDK/pdk_installed/tsmc65_gp/tsmcN65/../models/spectre/crn65gplus_2d5_lk_v1d0.scs" section=tt_rfjvar
include "/data/PDK/pdk_installed/tsmc65_gp/tsmcN65/../models/spectre/crn65gplus_2d5_lk_v1d0.scs" section=tt_rfmos_25
include "/data/PDK/pdk_installed/tsmc65_gp/tsmcN65/../models/spectre/crn65gplus_2d5_lk_v1d0.scs" section=tt_rtmom
include "/data/PDK/pdk_installed/tsmc65_gp/tsmcN65/../models/spectre/crn65gplus_2d5_lk_v1d0.scs" section=tt_na25od33
include "/data/PDK/pdk_installed/tsmc65_gp/tsmcN65/../models/spectre/crn65gplus_2d5_lk_v1d0.scs" section=tt_dio_na25
include "/data/PDK/pdk_installed/tsmc65_gp/tsmcN65/../models/spectre/crn65gplus_2d5_lk_v1d0.scs" section=tt_rfres_rpo
include "/data/PDK/pdk_installed/tsmc65_gp/tsmcN65/../models/spectre/crn65gplus_2d5_lk_v1d0.scs" section=tt_hvt
include "/data/PDK/pdk_installed/tsmc65_gp/tsmcN65/../models/spectre/crn65gplus_2d5_lk_v1d0.scs" section=tt_rfind
include "/data/PDK/pdk_installed/tsmc65_gp/tsmcN65/../models/spectre/crn65gplus_2d5_lk_v1d0.scs" section=tt_rfmvar_25
include "/data/PDK/pdk_installed/tsmc65_gp/tsmcN65/../models/spectre/crn65gplus_2d5_lk_v1d0.scs" section=tt_na25
include "/data/PDK/pdk_installed/tsmc65_gp/tsmcN65/../models/spectre/crn65gplus_2d5_lk_v1d0.scs" section=tt_lvt
// LDO_TCASII_Debashis_N65/LDO_Core/schematic
subckt LDO_Core VB1 VB2 VB3 VFB VIN VOUT VREF VSS
    M30 (net22 net23 VOUT VSS) nch_mac l=l_M30 w=w_M30_per_finger*nf_M30 multi=1 nf=nf_M30 sigma=1 mismatchflag=1
    M60 (net38 net38 VSS VSS) nch_mac l=l_M60 w=w_M60_per_finger*nf_M60 multi=1 nf=nf_M60 sigma=1 mismatchflag=1
    M64 (net30 net38 VSS VSS) nch_mac l=l_M64 w=w_M64_per_finger*nf_M64 multi=1 nf=nf_M64 sigma=1 mismatchflag=1
    M6 (net23 VB2 net30 VSS) nch_mac l=l_M6 w=w_M6_per_finger*nf_M6 multi=1 nf=nf_M6 sigma=1 mismatchflag=1
    M5 (net15 VB2 net35 VSS) nch_mac l=l_M5 w=w_M5_per_finger*nf_M5 multi=1 nf=nf_M5 sigma=1 mismatchflag=1
    M24 (net30 VB1 VSS VSS) nch_mac l=l_M24 w=w_M24_per_finger*nf_M24 multi=1 nf=nf_M24 sigma=1 mismatchflag=1
    M23 (net35 VB1 VSS VSS) nch_mac l=l_M23 w=w_M23_per_finger*nf_M23 multi=1 nf=nf_M23 sigma=1 mismatchflag=1
    M63 (net35 net38 VSS VSS) nch_mac l=l_M63 w=w_M63_per_finger*nf_M63 multi=1 nf=nf_M63 sigma=1 mismatchflag=1
    M62 (net10 net38 VSS VSS) nch_mac l=l_M62 w=w_M62_per_finger*nf_M62 multi=1 nf=nf_M62 sigma=1 mismatchflag=1
    M61 (net6 net38 VSS VSS) nch_mac l=l_M61 w=w_M61_per_finger*nf_M61 multi=1 nf=nf_M61 sigma=1 mismatchflag=1
    M21 (net6 VB1 VSS VSS) nch_mac l=l_M21 w=w_M21_per_finger*nf_M21 multi=1 nf=nf_M21 sigma=1 mismatchflag=1
    M22 (net10 VB1 VSS VSS) nch_mac l=l_M22 w=w_M22_per_finger*nf_M22 multi=1 nf=nf_M22 sigma=1 mismatchflag=1
    M0 (VIN net23 VOUT VSS) nch_mac l=l_M0 w=w_M0_per_finger*nf_M0 multi=1 nf=nf_M0 sigma=1 mismatchflag=1
    M11 (net22 net22 VPUMP VIN) pch_mac l=l_M11 w=w_M11_per_finger*nf_M11 multi=1 nf=nf_M11 sigma=1 mismatchflag=1
    M12 (net38 net22 VPUMP VIN) pch_mac l=l_M12 w=w_M12_per_finger*nf_M12 multi=1 nf=nf_M12 sigma=1 mismatchflag=1
    M10 (net45 net15 VPUMP VIN) pch_mac l=l_M10 w=w_M10_per_finger*nf_M10 multi=1 nf=nf_M10 sigma=1 mismatchflag=1
    M9 (net44 net15 VPUMP VIN) pch_mac l=l_M9 w=w_M9_per_finger*nf_M9 multi=1 nf=nf_M9 sigma=1 mismatchflag=1
    M7 (net15 VB3 net44 VIN) pch_mac l=l_M7 w=w_M7_per_finger*nf_M7 multi=1 nf=nf_M7 sigma=1 mismatchflag=1
    M8 (net23 VB3 net45 VIN) pch_mac l=l_M8 w=w_M8_per_finger*nf_M8 multi=1 nf=nf_M8 sigma=1 mismatchflag=1
    M42 (net10 net10 VREF VIN) pch_mac l=l_M42 w=w_M42_per_finger*nf_M42 multi=1 nf=nf_M42 sigma=1 mismatchflag=1
    M41 (net6 net6 VFB VIN) pch_mac l=l_M41 w=w_M41_per_finger*nf_M41 multi=1 nf=nf_M41 sigma=1 mismatchflag=1
    M2 (net35 net10 VFB VIN) pch_mac l=l_M2 w=w_M2_per_finger*nf_M2 multi=1 nf=nf_M2 sigma=1 mismatchflag=1
    M1 (net30 net6 VREF VIN) pch_mac l=l_M1 w=w_M1_per_finger*nf_M1 multi=1 nf=nf_M1 sigma=1 mismatchflag=1
    C0 (net43 VSS) capacitor c=CC
    R0 (net23 net43) resistor r=RC
    E0 (VPUMP VSS VIN VSS) vcvs gain=2.0
ends LDO_Core
// LDO_TCASII_Debashis_N65/tb_Trans_9m/schematic
V3 (VB1 0) vsource dc=VB1 type=dc
V5 (VB3 0) vsource dc=VB3 type=dc
V4 (VB2 0) vsource dc=VB2 type=dc
V2 (VIN 0) vsource dc=1.8 type=dc
V1 (VREF 0) vsource dc=1.6 type=dc
V0 (VSS 0) vsource dc=0 type=dc
I0 (VB1 VB2 VB3 VOUT VIN VOUT VREF VSS) LDO_Core
C0 (VOUT VSS) capacitor c=50p
I1 (VOUT VSS) isource dc=20m type=pulse val0=9m val1=40m period=20u delay=5u rise=350.00p fall=350.00p width=5u
simulatorOptions options temp=27
tran tran stop=15u errpreset=conservative
save I1:sink
