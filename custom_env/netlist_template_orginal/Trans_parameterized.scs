// Design: LDO_SSF_Ideal_Source/tb_LDO_Trans
simulator lang=spectre
global 0
parameters VB_1 VB_2 CAP_CMP RES_CMP IBN_EA I_MAX=200m VDD=2 w_M9_per_finger l_M9 nf_M9 w_M5_per_finger l_M5 nf_M5 w_M3_per_finger l_M3 nf_M3 w_M15_per_finger l_M15 nf_M15 w_M26_per_finger l_M26 nf_M26 w_M14_per_finger l_M14 nf_M14 w_M24_per_finger l_M24 nf_M24 w_M19_per_finger l_M19 nf_M19 w_M2_per_finger l_M2 nf_M2 w_M16_per_finger l_M16 nf_M16 w_M12_per_finger l_M12 nf_M12 w_M8_per_finger l_M8 nf_M8 w_M13_per_finger l_M13 nf_M13 w_M4_per_finger l_M4 nf_M4 w_M17_per_finger l_M17 nf_M17 w_M25_per_finger l_M25 nf_M25 w_M1_per_finger l_M1 nf_M1 w_M18_per_finger l_M18 nf_M18 w_M6_per_finger l_M6 nf_M6 w_M7_per_finger l_M7 nf_M7 w_M0_per_finger l_M0 nf_M0
include "/data/PDK/pdk_installed/tsmc180bcd_g2/pdk/pdk_1p6m_2/tsmc18/../models/spectre/c018bcd_gen2_v1d6_usage.scs" section=pre_simu
include "/data/PDK/pdk_installed/tsmc180bcd_g2/pdk/pdk_1p6m_2/tsmc18/../models/spectre/c018bcd_gen2_v1d6_usage.scs" section=tt_lib
// LDO_SSF_Ideal_Source/EA_Core/schematic
subckt EA_Core IBN_EA VB_1 VB_2 VDD VEA VFB VG VREF VSS
    M9 (VG IBP_BUF1 VDD VDD) pch_mac l=l_M9 w=w_M9_per_finger*nf_M9 multi=1 nf=nf_M9 sigma=1 mismatchflag=1
    M5 (IBP_BUF1 IBP_BUF1 VDD VDD) pch_mac l=l_M5 w=w_M5_per_finger*nf_M5 multi=1 nf=nf_M5 sigma=1 mismatchflag=1
    M3 (IBP_BUF2 VEA VG VDD) pch_mac l=l_M3 w=w_M3_per_finger*nf_M3 multi=1 nf=nf_M3 sigma=1 mismatchflag=1
    M15 (VBP_TAIL VBP_TAIL VDD VDD) pch_mac l=l_M15 w=w_M15_per_finger*nf_M15 multi=1 nf=nf_M15 sigma=1 mismatchflag=1
    M26 (net128 VBP_TAIL VDD VDD) pch_mac l=l_M26 w=w_M26_per_finger*nf_M26 multi=1 nf=nf_M26 sigma=1 mismatchflag=1
    M14 (net125 VBP_TAIL VDD VDD) pch_mac l=l_M14 w=w_M14_per_finger*nf_M14 multi=1 nf=nf_M14 sigma=1 mismatchflag=1
    M24 (VEA VB_2 net128 VDD) pch_mac l=l_M24 w=w_M24_per_finger*nf_M24 multi=1 nf=nf_M24 sigma=1 mismatchflag=1
    M19 (net126 VB_2 net125 VDD) pch_mac l=l_M19 w=w_M19_per_finger*nf_M19 multi=1 nf=nf_M19 sigma=1 mismatchflag=1
    M2 (net128 VREF net66 net66) nch_mac l=l_M2 w=w_M2_per_finger*nf_M2 multi=1 nf=nf_M2 sigma=1 mismatchflag=1
    M16 (IBN_EA IBN_EA VSS VSS) nch_mac l=l_M16 w=w_M16_per_finger*nf_M16 multi=1 nf=nf_M16 sigma=1 mismatchflag=1
    M12 (IBP_BUF2 IBN_EA VSS VSS) nch_mac l=l_M12 w=w_M12_per_finger*nf_M12 multi=1 nf=nf_M12 sigma=1 mismatchflag=1
    M8 (IBP_BUF1 IBN_EA VSS VSS) nch_mac l=l_M8 w=w_M8_per_finger*nf_M8 multi=1 nf=nf_M8 sigma=1 mismatchflag=1
    M13 (net66 IBN_EA VSS VSS) nch_mac l=l_M13 w=w_M13_per_finger*nf_M13 multi=1 nf=nf_M13 sigma=1 mismatchflag=1
    M4 (VBP_TAIL IBN_EA VSS VSS) nch_mac l=l_M4 w=w_M4_per_finger*nf_M4 multi=1 nf=nf_M4 sigma=1 mismatchflag=1
    M17 (net126 VB_1 net124 VSS) nch_mac l=l_M17 w=w_M17_per_finger*nf_M17 multi=1 nf=nf_M17 sigma=1 mismatchflag=1
    M25 (VG IBP_BUF2 VSS VSS) nch_mac l=l_M25 w=w_M25_per_finger*nf_M25 multi=1 nf=nf_M25 sigma=1 mismatchflag=1
    M1 (net125 VFB net66 net66) nch_mac l=l_M1 w=w_M1_per_finger*nf_M1 multi=1 nf=nf_M1 sigma=1 mismatchflag=1
    M18 (VEA VB_1 net127 VSS) nch_mac l=l_M18 w=w_M18_per_finger*nf_M18 multi=1 nf=nf_M18 sigma=1 mismatchflag=1
    M6 (net124 net126 VSS VSS) nch_mac l=l_M6 w=w_M6_per_finger*nf_M6 multi=1 nf=nf_M6 sigma=1 mismatchflag=1
    M7 (net127 net126 VSS VSS) nch_mac l=l_M7 w=w_M7_per_finger*nf_M7 multi=1 nf=nf_M7 sigma=1 mismatchflag=1
ends EA_Core
// LDO_SSF_Ideal_Source/tb_LDO_Trans/schematic
V0 (VB_1 VSS) vsource dc=VB_1 type=dc
V1 (VB_2 VSS) vsource dc=VB_2 type=dc
VIN2 (VDD 0) vsource dc=VDD type=dc
V3 (VSS 0) vsource dc=0 type=dc
V2 (VREF VSS) vsource dc=1.2 type=dc
I4 (VREF IBN_EA) isource dc=IBN_EA type=dc
C1 (VEA net016) capacitor c=CAP_CMP
C0 (VOUT VSS) capacitor c=10n
R1 (VSS VOUT) resistor r=100K
R0 (net016 VOUT) resistor r=RES_CMP
I19 (VOUT VSS) isource type=pulse val0=500.0u val1=I_MAX period=20u delay=2u rise=1n fall=1n width=10u
I8 (IBN_EA VB_1 VB_2 VDD VEA VOUT VG VREF VSS) EA_Core
M0 (VOUT VG VDD VDD) pch_mac l=l_M0 w=w_M0_per_finger*nf_M0 multi=1 nf=nf_M0 sigma=1 mismatchflag=1
simulatorOptions options temp=27
tran tran stop=20u errpreset=conservative
save I19:sink
