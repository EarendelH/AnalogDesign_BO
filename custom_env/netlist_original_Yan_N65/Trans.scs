// Design: LDO_TCASI_Yan_N65/tb_Trans
simulator lang=spectre
global 0
parameters C1 CB IB
include "~/spectre_N65/crn65gplus_2d5_lk_v1d0.scs" section=tt_bip
include "~/spectre_N65/crn65gplus_2d5_lk_v1d0.scs" section=tt_dio
include "~/spectre_N65/crn65gplus_2d5_lk_v1d0.scs" section=tt_dio_33
include "~/spectre_N65/crn65gplus_2d5_lk_v1d0.scs" section=tt_mim
include "~/spectre_N65/crn65gplus_2d5_lk_v1d0.scs" section=tt_dio_dnw
include "~/spectre_N65/crn65gplus_2d5_lk_v1d0.scs" section=tt_dio_18
include "~/spectre_N65/crn65gplus_2d5_lk_v1d0.scs" section=tt_bip_npn
include "~/spectre_N65/crn65gplus_2d5_lk_v1d0.scs" section=tt_33
include "~/spectre_N65/crn65gplus_2d5_lk_v1d0.scs" section=tt_rfrtmom
include "~/spectre_N65/crn65gplus_2d5_lk_v1d0.scs" section=tt_mos_cap_25
include "~/spectre_N65/crn65gplus_2d5_lk_v1d0.scs" section=tt_18
include "~/spectre_N65/crn65gplus_2d5_lk_v1d0.scs" section=tt_disres
include "~/spectre_N65/crn65gplus_2d5_lk_v1d0.scs" section=tt_res
include "~/spectre_N65/crn65gplus_2d5_lk_v1d0.scs" section=tt_dio_na
include "~/spectre_N65/crn65gplus_2d5_lk_v1d0.scs" section=tt_rfmos_33
include "~/spectre_N65/crn65gplus_2d5_lk_v1d0.scs" section=tt_dio_hvt
include "~/spectre_N65/crn65gplus_2d5_lk_v1d0.scs" section=tt_rfmvar
include "~/spectre_N65/crn65gplus_2d5_lk_v1d0.scs" section=tt_rfmos_18
include "~/spectre_N65/crn65gplus_2d5_lk_v1d0.scs" section=tt_na
include "~/spectre_N65/crn65gplus_2d5_lk_v1d0.scs" section=tt_dio_na33
include "~/spectre_N65/crn65gplus_2d5_lk_v1d0.scs" section=tt_dio_lvt
include "~/spectre_N65/crn65gplus_2d5_lk_v1d0.scs" section=tt_rfres_sa
include "~/spectre_N65/crn65gplus_2d5_lk_v1d0.scs" section=tt_na33
include "~/spectre_N65/crn65gplus_2d5_lk_v1d0.scs" section=tt_dio_esd
include "~/spectre_N65/crn65gplus_2d5_lk_v1d0.scs" section=tt_rfmim
include "~/spectre_N65/crn65gplus_2d5_lk_v1d0.scs" section=tt_dio_25od33
include "~/spectre_N65/crn65gplus_2d5_lk_v1d0.scs" section=tt_25od33
include "~/spectre_N65/crn65gplus_2d5_lk_v1d0.scs" section=tt
include "~/spectre_N65/crn65gplus_2d5_lk_v1d0.scs" section=tt_mos_cap
include "~/spectre_N65/crn65gplus_2d5_lk_v1d0.scs" section=tt_dio_25
include "~/spectre_N65/crn65gplus_2d5_lk_v1d0.scs" section=tt_dio_25ud18
include "~/spectre_N65/crn65gplus_2d5_lk_v1d0.scs" section=tt_25
include "~/spectre_N65/crn65gplus_2d5_lk_v1d0.scs" section=tt_rfmos
include "~/spectre_N65/crn65gplus_2d5_lk_v1d0.scs" section=tt_25ud18
include "~/spectre_N65/crn65gplus_2d5_lk_v1d0.scs" section=tt_dio_na25od33
include "~/spectre_N65/crn65gplus_2d5_lk_v1d0.scs" section=tt_rfjvar
include "~/spectre_N65/crn65gplus_2d5_lk_v1d0.scs" section=tt_rfmos_25
include "~/spectre_N65/crn65gplus_2d5_lk_v1d0.scs" section=tt_rtmom
include "~/spectre_N65/crn65gplus_2d5_lk_v1d0.scs" section=tt_na25od33
include "~/spectre_N65/crn65gplus_2d5_lk_v1d0.scs" section=tt_dio_na25
include "~/spectre_N65/crn65gplus_2d5_lk_v1d0.scs" section=tt_rfres_rpo
include "~/spectre_N65/crn65gplus_2d5_lk_v1d0.scs" section=tt_hvt
include "~/spectre_N65/crn65gplus_2d5_lk_v1d0.scs" section=tt_rfind
include "~/spectre_N65/crn65gplus_2d5_lk_v1d0.scs" section=tt_rfmvar_25
include "~/spectre_N65/crn65gplus_2d5_lk_v1d0.scs" section=tt_na25
include "~/spectre_N65/crn65gplus_2d5_lk_v1d0.scs" section=tt_lvt

// LDO_TCASI_Yan_N65/LDO_Core/schematic
subckt LDO_Core VFB VIN VOUT VREF VSS
    M15 (net28 net27 VSS VSS) nch_mac l=60n w=200n multi=1 nf=1 sigma=1 mismatchflag=1
    M16 (net50 net27 VSS VSS) nch_mac l=60n w=200n multi=1 nf=1 sigma=1 mismatchflag=1
    M12 (net34 net27 VSS VSS) nch_mac l=60n w=200n multi=1 nf=1 sigma=1 mismatchflag=1
    M11 (net37 net34 VSS VSS) nch_mac l=60n w=200n multi=1 nf=1 sigma=1 mismatchflag=1
    M19 (net19 net7 VSS VSS) nch_mac l=60n w=200n multi=1 nf=1 sigma=1 mismatchflag=1
    M20 (net15 net7 VSS VSS) nch_mac l=60n w=200n multi=1 nf=1 sigma=1 mismatchflag=1
    M21 (net7 net7 VSS VSS) nch_mac l=60n w=200n multi=1 nf=1 sigma=1 mismatchflag=1
    M14 (net27 net27 VSS VSS) nch_mac l=60n w=200n multi=1 nf=1 sigma=1 mismatchflag=1
    M3 (net20 VFB net19 VSS) nch_mac l=60n w=200n multi=1 nf=1 sigma=1 mismatchflag=1
    M2 (net20 net48 net19 VSS) nch_mac l=60n w=200n multi=1 nf=1 sigma=1 mismatchflag=1
    M1 (net16 VREF net19 VSS) nch_mac l=60n w=200n multi=1 nf=1 sigma=1 mismatchflag=1
    M0 (VOUT net37 VIN VIN) pch_mac l=60n w=200n multi=1 nf=1 sigma=1 mismatchflag=1
    M18 (net15 net15 VIN VIN) pch_mac l=60n w=200n multi=1 nf=1 sigma=1 mismatchflag=1
    M17 (net27 net15 VIN VIN) pch_mac l=60n w=200n multi=1 nf=1 sigma=1 mismatchflag=1
    M13 (net37 net15 VIN VIN) pch_mac l=60n w=200n multi=1 nf=1 sigma=1 mismatchflag=1
    M10 (net37 net37 VIN VIN) pch_mac l=60n w=200n multi=1 nf=1 sigma=1 mismatchflag=1
    M9 (net34 net50 net37 VIN) pch_mac l=60n w=200n multi=1 nf=1 sigma=1 mismatchflag=1
    M8 (net50 net28 VFB VIN) pch_mac l=60n w=200n multi=1 nf=1 sigma=1 mismatchflag=1
    M7 (net28 net28 net48 VIN) pch_mac l=60n w=200n multi=1 nf=1 sigma=1 mismatchflag=1
    M6 (net48 net16 VIN VIN) pch_mac l=60n w=200n multi=1 nf=1 sigma=1 mismatchflag=1
    M5 (net20 net20 VIN VIN) pch_mac l=60n w=200n multi=1 nf=1 sigma=1 mismatchflag=1
    M4 (net16 net20 VIN VIN) pch_mac l=60n w=200n multi=1 nf=1 sigma=1 mismatchflag=1
    CB (net28 VSS) capacitor c=CB
    C1 (net7 VSS) capacitor c=C1
    I0 (VIN net7) isource dc=IB type=dc
ends LDO_Core

// LDO_TCASI_Yan_N65/tb_Trans/schematic
I0 (VOUT VIN VOUT VREF VSS) LDO_Core
V2 (VIN 0) vsource dc=1.2 type=dc
V1 (VREF 0) vsource dc=1 type=dc
V0 (VSS 0) vsource dc=0 type=dc
C3 (VOUT VSS) capacitor c=130p
I1 (VOUT VSS) isource dc=10m type=pulse val0=0 val1=10m period=20u delay=5u rise=200.0p fall=200.0p width=5u
simulatorOptions options temp=27
tran tran stop=15u errpreset=conservative
save I1:sink
