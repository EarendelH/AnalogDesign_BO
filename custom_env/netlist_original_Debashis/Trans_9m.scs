// Design: LDO_TCASII_Debashis/tb_Trans_9m
simulator lang=spectre
global 0
parameters VB1 VB2 VB3 CC RC
include "/data/PDK/pdk_installed/tsmc180bcd_g2/pdk/pdk_1p6m_2/tsmc18/../models/spectre/c018bcd_gen2_v1d6_usage.scs" section=pre_simu
include "/data/PDK/pdk_installed/tsmc180bcd_g2/pdk/pdk_1p6m_2/tsmc18/../models/spectre/c018bcd_gen2_v1d6_usage.scs" section=tt_lib

// LDO_TCASII_Debashis/LDO_Core/schematic
subckt LDO_Core VB1 VB2 VB3 VFB VIN VOUT VREF VSS
    M30 (net22 net23 VOUT VSS) nch_mac l=180n w=2u multi=1 nf=1 sigma=1 mismatchflag=1
    M60 (net38 net38 VSS VSS) nch_mac l=180n w=2u multi=1 nf=1 sigma=1 mismatchflag=1
    M64 (net30 net38 VSS VSS) nch_mac l=180n w=2u multi=1 nf=1 sigma=1 mismatchflag=1
    M6 (net23 VB2 net30 VSS) nch_mac l=180n w=2u multi=1 nf=1 sigma=1 mismatchflag=1
    M5 (net15 VB2 net35 VSS) nch_mac l=180n w=2u multi=1 nf=1 sigma=1 mismatchflag=1
    M24 (net30 VB1 VSS VSS) nch_mac l=180n w=2u multi=1 nf=1 sigma=1 mismatchflag=1
    M23 (net35 VB1 VSS VSS) nch_mac l=180n w=2u multi=1 nf=1 sigma=1 mismatchflag=1
    M63 (net35 net38 VSS VSS) nch_mac l=180n w=2u multi=1 nf=1 sigma=1 mismatchflag=1
    M62 (net10 net38 VSS VSS) nch_mac l=180n w=2u multi=1 nf=1 sigma=1 mismatchflag=1
    M61 (net6 net38 VSS VSS) nch_mac l=180n w=2u multi=1 nf=1 sigma=1 mismatchflag=1
    M21 (net6 VB1 VSS VSS) nch_mac l=180n w=2u multi=1 nf=1 sigma=1 mismatchflag=1
    M22 (net10 VB1 VSS VSS) nch_mac l=180n w=2u multi=1 nf=1 sigma=1 mismatchflag=1
    M0 (VIN net23 VOUT VSS) nch_mac l=180n w=2u multi=1 nf=1 sigma=1 mismatchflag=1
    M11 (net22 net22 VPUMP VIN) pch_mac l=180n w=2u multi=1 nf=1 sigma=1 mismatchflag=1
    M12 (net38 net22 VPUMP VIN) pch_mac l=180n w=2u multi=1 nf=1 sigma=1 mismatchflag=1
    M10 (net45 net15 VPUMP VIN) pch_mac l=180n w=2u multi=1 nf=1 sigma=1 mismatchflag=1
    M9 (net44 net15 VPUMP VIN) pch_mac l=180n w=2u multi=1 nf=1 sigma=1 mismatchflag=1
    M7 (net15 VB3 net44 VIN) pch_mac l=180n w=2u multi=1 nf=1 sigma=1 mismatchflag=1
    M8 (net23 VB3 net45 VIN) pch_mac l=180n w=2u multi=1 nf=1 sigma=1 mismatchflag=1
    M42 (net10 net10 VREF VIN) pch_mac l=180n w=2u multi=1 nf=1 sigma=1 mismatchflag=1
    M41 (net6 net6 VFB VIN) pch_mac l=180n w=2u multi=1 nf=1 sigma=1 mismatchflag=1
    M2 (net35 net10 VFB VIN) pch_mac l=180n w=2u multi=1 nf=1 sigma=1 mismatchflag=1
    M1 (net30 net6 VREF VIN) pch_mac l=180n w=2u multi=1 nf=1 sigma=1 mismatchflag=1
    C0 (net43 VSS) capacitor c=CC
    R0 (net23 net43) resistor r=RC
    E0 (VPUMP VSS VIN VSS) vcvs gain=2.0
ends LDO_Core

// LDO_TCASII_Debashis/tb_Trans_9m/schematic
V3 (VB1 0) vsource dc=VB1 type=dc
V5 (VB3 0) vsource dc=VB3 type=dc
V4 (VB2 0) vsource dc=VB2 type=dc
V2 (VIN 0) vsource dc=1.8 type=dc
V1 (VREF 0) vsource dc=1.6 type=dc
V0 (VSS 0) vsource dc=0 type=dc
I0 (VB1 VB2 VB3 VOUT VIN VOUT VREF VSS) LDO_Core
C0 (VOUT VSS) capacitor c=50p
I1 (VOUT VSS) isource dc=20m type=pulse val0=9m val1=40m period=20u delay=5u rise=350.00p fall=350.00p width=5u
simulatorOptions options temp=27
tran tran stop=15u errpreset=conservative
save I1:sink
