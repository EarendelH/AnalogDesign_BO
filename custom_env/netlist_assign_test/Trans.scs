// Design: LDO/tb_transit
simulator lang=spectre
global 0
parameters Delta=0.1 VCM=0.9 IB=50.0u l_M14=1.5u w_M14=3.0u nf_M14=3 l_M35=1.0u w_M35=4.5u nf_M35=3 l_M25=1.5u w_M25=3.0u nf_M25=2 l_M13=4.5u w_M13=18.0u nf_M13=4 l_M12=1.0u w_M12=1.5u nf_M12=1 l_M11=0.5u w_M11=1.0u nf_M11=2 l_M20=1.0u w_M20=1.0u nf_M20=1 l_M19=1.0u w_M19=4.5u nf_M19=3 l_M36=0.5u w_M36=4.5u nf_M36=3 l_M16=1.5u w_M16=3.0u nf_M16=3 l_M24=1.0u w_M24=2.0u nf_M24=2 l_M23=0.5u w_M23=0.5u nf_M23=1 l_M22=1.5u w_M22=1.0u nf_M22=2 l_M21=1.0u w_M21=1.0u nf_M21=1 l_M18=1.5u w_M18=2.0u nf_M18=2 l_M17=1.0u w_M17=3.0u nf_M17=2
include "/data/PDK/pdk_installed/tsmc180bcd_g2/pdk/pdk_1p6m/tsmc18/../models/spectre/c018bcd_gen2_v1d6_usage.scs" section=pre_simu
include "/data/PDK/pdk_installed/tsmc180bcd_g2/pdk/pdk_1p6m/tsmc18/../models/spectre/c018bcd_gen2_v1d6_usage.scs" section=tt_lib

// LDO/OPP_w_fixed_bias/schematic
subckt OPP_w_fixed_bias GND IBP INN INP OUT VDD
    M14 (net33 net20 GND GND) nch_mac l=l_M14 w=w_M14 multi=1 nf=nf_M14 sigma=1 mismatchflag=1
    M35 (VB1 VB1 GND GND) nch_mac l=l_M35 w=w_M35 multi=1 nf=nf_M35 sigma=1 mismatchflag=1
    M25 (net20 net20 GND GND) nch_mac l=l_M25 w=w_M25 multi=1 nf=nf_M25 sigma=1 mismatchflag=1
    M13 (net34 net20 GND GND) nch_mac l=l_M13 w=w_M13 multi=1 nf=nf_M13 sigma=1 mismatchflag=1
    M12 (net27 VB1 net34 GND) nch_mac l=l_M12 w=w_M12 multi=1 nf=nf_M12 sigma=1 mismatchflag=1
    M11 (OUT VB1 net33 GND) nch_mac l=l_M11 w=w_M11 multi=1 nf=nf_M11 sigma=1 mismatchflag=1
    M20 (net28 net28 VDD VDD) pch_mac l=l_M20 w=w_M20 multi=1 nf=nf_M20 sigma=1 mismatchflag=1
    M19 (net36 net28 VDD VDD) pch_mac l=l_M19 w=w_M19 multi=1 nf=nf_M19 sigma=1 mismatchflag=1
    M36 (VB1 IBP VDD VDD) pch_mac l=l_M36 w=w_M36 multi=1 nf=nf_M36 sigma=1 mismatchflag=1
    M16 (net11 IBP VDD VDD) pch_mac l=l_M16 w=w_M16 multi=1 nf=nf_M16 sigma=1 mismatchflag=1
    M24 (net20 IBP VDD VDD) pch_mac l=l_M24 w=w_M24 multi=1 nf=nf_M24 sigma=1 mismatchflag=1
    M23 (IBP IBP VDD VDD) pch_mac l=l_M23 w=w_M23 multi=1 nf=nf_M23 sigma=1 mismatchflag=1
    M22 (net27 net27 net28 VDD) pch_mac l=l_M22 w=w_M22 multi=1 nf=nf_M22 sigma=1 mismatchflag=1
    M21 (OUT net27 net36 VDD) pch_mac l=l_M21 w=w_M21 multi=1 nf=nf_M21 sigma=1 mismatchflag=1
    M18 (net34 INP net11 VDD) pch_mac l=l_M18 w=w_M18 multi=1 nf=nf_M18 sigma=1 mismatchflag=1
    M17 (net33 INN net11 VDD) pch_mac l=l_M17 w=w_M17 multi=1 nf=nf_M17 sigma=1 mismatchflag=1
ends OPP_w_fixed_bias

// LDO/tb_transit/schematic
C0 (net3 0) capacitor c=50f
I10 (net06 0) isource dc=IB type=dc
V3 (net07 0) vsource dc=900.0m type=dc
V0 (net6 0) vsource dc=1.8 type=dc
I9 (0 net06 net3 net05 net3 net6) OPP_w_fixed_bias
V1 (net05 net07) vsource type=pulse val0=-100m val1=100.0m period=1u delay=500.0n rise=1n fall=1n width=500.0n
simulatorOptions options temp=27
tran tran stop=2u errpreset=conservative
