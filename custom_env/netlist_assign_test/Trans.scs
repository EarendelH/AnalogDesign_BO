// Design: LDO_SSF_Ideal_Source/tb_LDO_Trans
simulator lang=spectre
global 0
parameters VB_1 VB_2 CAP_CMP RES_CMP IBN_EA ILOAD=0 VDD=2 I_MAX=200m
include "/data/PDK/pdk_installed/tsmc180bcd_g2/pdk/pdk_1p6m_2/tsmc18/../models/spectre/c018bcd_gen2_v1d6_usage.scs" section=pre_simu
include "/data/PDK/pdk_installed/tsmc180bcd_g2/pdk/pdk_1p6m_2/tsmc18/../models/spectre/c018bcd_gen2_v1d6_usage.scs" section=tt_lib

// LDO_SSF_Ideal_Source/EA_Core/schematic
subckt EA_Core IBN_EA VB_1 VB_2 VDD VEA VFB VG VREF VSS
    M9 (VG IBP_BUF1 VDD VDD) pch_mac l=500n w=2u multi=2 nf=1 sigma=1 mismatchflag=1
    M5 (IBP_BUF1 IBP_BUF1 VDD VDD) pch_mac l=500n w=2u multi=1 nf=1 sigma=1 mismatchflag=1
    M3 (IBP_BUF2 VEA VG VDD) pch_mac l=180.0n w=2u multi=4 nf=1 sigma=1 mismatchflag=1
    M15 (VBP_TAIL VBP_TAIL VDD VDD) pch_mac l=500n w=4u multi=1 nf=1 sigma=1 mismatchflag=1
    M26 (net128 VBP_TAIL VDD VDD) pch_mac l=500n w=4u multi=3 nf=1 sigma=1 mismatchflag=1
    M14 (net125 VBP_TAIL VDD VDD) pch_mac l=500n w=4u multi=3 nf=1 sigma=1 mismatchflag=1
    M24 (VEA VB_2 net128 VDD) pch_mac l=180.0n w=4u multi=2 nf=1 sigma=1 mismatchflag=1
    M19 (net126 VB_2 net125 VDD) pch_mac l=180.0n w=4u multi=2 nf=1 sigma=1 mismatchflag=1
    M2 (net128 VREF net66 net66) nch_mac l=500n w=5u multi=6 nf=1 sigma=1 mismatchflag=1
    M16 (IBN_EA IBN_EA VSS VSS) nch_mac l=1u w=2u multi=5 nf=1 sigma=1 mismatchflag=1
    M12 (IBP_BUF2 IBN_EA VSS VSS) nch_mac l=1u w=2u multi=1 nf=1 sigma=1 mismatchflag=1
    M8 (IBP_BUF1 IBN_EA VSS VSS) nch_mac l=1u w=2u multi=1 nf=1 sigma=1 mismatchflag=1
    M13 (net66 IBN_EA VSS VSS) nch_mac l=1u w=2u multi=5 nf=1 sigma=1 mismatchflag=1
    M4 (VBP_TAIL IBN_EA VSS VSS) nch_mac l=1u w=2u multi=1 nf=1 sigma=1 mismatchflag=1
    M17 (net126 VB_1 net124 VSS) nch_mac l=180.0n w=2u multi=2 nf=1 sigma=1 mismatchflag=1
    M25 (VG IBP_BUF2 VSS VSS) nch_mac l=180.0n w=4u multi=1 nf=1 sigma=1 mismatchflag=1
    M1 (net125 VFB net66 net66) nch_mac l=500n w=5u multi=6 nf=1 sigma=1 mismatchflag=1
    M18 (VEA VB_1 net127 VSS) nch_mac l=180.0n w=2u multi=2 nf=1 sigma=1 mismatchflag=1
    M6 (net124 net126 VSS VSS) nch_mac l=1u w=2u multi=1 nf=1 sigma=1 mismatchflag=1
    M7 (net127 net126 VSS VSS) nch_mac l=1u w=2u multi=1 nf=1 sigma=1 mismatchflag=1
ends EA_Core

// LDO_SSF_Ideal_Source/tb_LDO_Trans/schematic
V0 (VB_1 VSS) vsource dc=VB_1 type=dc
V1 (VB_2 VSS) vsource dc=VB_2 type=dc
VIN2 (VDD 0) vsource dc=VDD type=dc
V3 (VSS 0) vsource dc=0 type=dc
V2 (VREF VSS) vsource dc=1.2 type=dc
I4 (VREF IBN_EA) isource dc=IBN_EA type=dc
C1 (VEA net016) capacitor c=CAP_CMP
C0 (VOUT VSS) capacitor c=10n
R1 (VSS VOUT) resistor r=100K
R0 (net016 VOUT) resistor r=RES_CMP
I19 (VOUT VSS) isource type=pulse val0=500.0u val1=I_MAX period=20u delay=2u rise=1n fall=1n width=10u
I8 (IBN_EA VB_1 VB_2 VDD VEA VOUT VG VREF VSS) EA_Core
M0 (VOUT VG VDD VDD) pch_mac l=180.0n w=12.000m multi=1 nf=600 sigma=1 mismatchflag=1
simulatorOptions options temp=27
tran tran stop=20u errpreset=conservative
save I19:sink
