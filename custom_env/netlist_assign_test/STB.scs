// Design: LDO/tb_STB
simulator lang=spectre
global 0
parameters IBP=1u ILOAD=25m
include "/data/PDK/pdk_installed/tsmc180bcd_g2/pdk/pdk_1p6m_2/tsmc18/../models/spectre/c018bcd_gen2_v1d6_usage.scs" section=pre_simu
include "/data/PDK/pdk_installed/tsmc180bcd_g2/pdk/pdk_1p6m_2/tsmc18/../models/spectre/c018bcd_gen2_v1d6_usage.scs" section=tt_lib

// LDO/EA_LDO/schematic
subckt EA_LDO IBP INN INP VDD VOUT VSS
    M16 (VSS VSS VSS VSS) nch_5_mac l=1u w=2u multi=4 nf=1 sigma=1 mismatchflag=1
    M13 (net25 net25 VSS VSS) nch_5_mac l=2u w=2u multi=1 nf=1 sigma=1 mismatchflag=1
    M12 (net19 net21 VSS VSS) nch_5_mac l=2u w=2u multi=4 nf=1 sigma=1 mismatchflag=1
    M11 (net21 net21 VSS VSS) nch_5_mac l=2u w=2u multi=1 nf=1 sigma=1 mismatchflag=1
    M2 (VOUT net25 VSS VSS) nch_5_mac l=2u w=2u multi=4 nf=1 sigma=1 mismatchflag=1
    M20 (net017 net017 net017 VDD) pch_5_mac l=500n w=2u multi=4 nf=2 sigma=1 mismatchflag=1
    M21 (VDD VDD VDD VDD) pch_5_mac l=1u w=1u multi=2 nf=1 sigma=1 mismatchflag=1
    M10 (net25 INP net017 VDD) pch_5_mac l=500n w=2u multi=2 nf=1 sigma=1 mismatchflag=1
    M9 (net21 INN net017 VDD) pch_5_mac l=500n w=2u multi=2 nf=1 sigma=1 mismatchflag=1
    M6 (VOUT net19 VDD VDD) pch_5_mac l=2u w=2u multi=1 nf=1 sigma=1 mismatchflag=1
    M5 (net19 net19 VDD VDD) pch_5_mac l=2u w=2u multi=1 nf=1 sigma=1 mismatchflag=1
    M4 (IBP IBP VDD VDD) pch_5_mac l=1u w=1u multi=1 nf=1 sigma=1 mismatchflag=1
    M1 (net017 IBP VDD VDD) pch_5_mac l=1u w=1u multi=3 nf=1 sigma=1 mismatchflag=1
    M19 (VDD VDD VDD VDD) pch_5_mac l=2u w=2u multi=4 nf=1 sigma=1 mismatchflag=1
ends EA_LDO

// LDO/tb_STB/schematic
V0 (VDD 0) vsource dc=3.6 type=dc
V2 (VREF 0) vsource dc=1.2 type=dc
V1 (VSS 0) vsource dc=0 type=dc
I1 (VOUT VSS) isource dc=ILOAD type=dc
I0 (IBP 0) isource dc=IBP type=dc
I18 (IBP VREF net8 VDD VG VSS) EA_LDO
R0 (VOUT VFB) resistor r=12K
R1 (VFB VSS) resistor r=24K
C0 (VG VOUT) capacitor c=80p
C1 (VOUT VSS) capacitor c=1n
M0 (VOUT VG VDD VDD) pch_5 l=500n w=300.0000u m=1 nf=1
IPRB0 (VFB net8) iprobe
simulatorOptions options temp=27
stb stb start=1 stop=1G probe=IPRB0 localgnd=VSS
