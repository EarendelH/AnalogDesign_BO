// Design: LDO_TCASI_Yan/tb_Trans
simulator lang=spectre
global 0
parameters C1 CB IB w_M15_per_finger l_M15 nf_M15 w_M16_per_finger l_M16 nf_M16 w_M12_per_finger l_M12 nf_M12 w_M11_per_finger l_M11 nf_M11 w_M19_per_finger l_M19 nf_M19 w_M20_per_finger l_M20 nf_M20 w_M21_per_finger l_M21 nf_M21 w_M14_per_finger l_M14 nf_M14 w_M3_per_finger l_M3 nf_M3 w_M2_per_finger l_M2 nf_M2 w_M1_per_finger l_M1 nf_M1 w_M0_per_finger l_M0 nf_M0 w_M18_per_finger l_M18 nf_M18 w_M17_per_finger l_M17 nf_M17 w_M13_per_finger l_M13 nf_M13 w_M10_per_finger l_M10 nf_M10 w_M9_per_finger l_M9 nf_M9 w_M8_per_finger l_M8 nf_M8 w_M7_per_finger l_M7 nf_M7 w_M6_per_finger l_M6 nf_M6 w_M5_per_finger l_M5 nf_M5 w_M4_per_finger l_M4 nf_M4
include "/data/PDK/pdk_installed/tsmc180bcd_g2/pdk/pdk_1p6m_2/tsmc18/../models/spectre/c018bcd_gen2_v1d6_usage.scs" section=pre_simu
include "/data/PDK/pdk_installed/tsmc180bcd_g2/pdk/pdk_1p6m_2/tsmc18/../models/spectre/c018bcd_gen2_v1d6_usage.scs" section=tt_lib
// LDO_TCASI_Yan/LDO_Core/schematic
subckt LDO_Core VFB VIN VOUT VREF VSS
    M15 (net28 net27 net10 net10) nch_mac l=l_M15 w=w_M15_per_finger*nf_M15 multi=1 nf=nf_M15 sigma=1 mismatchflag=1
    M16 (net50 net27 net10 net10) nch_mac l=l_M16 w=w_M16_per_finger*nf_M16 multi=1 nf=nf_M16 sigma=1 mismatchflag=1
    M12 (net34 net27 net10 net10) nch_mac l=l_M12 w=w_M12_per_finger*nf_M12 multi=1 nf=nf_M12 sigma=1 mismatchflag=1
    M11 (net37 net34 net10 net10) nch_mac l=l_M11 w=w_M11_per_finger*nf_M11 multi=1 nf=nf_M11 sigma=1 mismatchflag=1
    M19 (net19 net7 net10 net10) nch_mac l=l_M19 w=w_M19_per_finger*nf_M19 multi=1 nf=nf_M19 sigma=1 mismatchflag=1
    M20 (net15 net7 net10 net10) nch_mac l=l_M20 w=w_M20_per_finger*nf_M20 multi=1 nf=nf_M20 sigma=1 mismatchflag=1
    M21 (net7 net7 net10 net10) nch_mac l=l_M21 w=w_M21_per_finger*nf_M21 multi=1 nf=nf_M21 sigma=1 mismatchflag=1
    M14 (net27 net27 net10 net10) nch_mac l=l_M14 w=w_M14_per_finger*nf_M14 multi=1 nf=nf_M14 sigma=1 mismatchflag=1
    M3 (net20 VFB net19 VSS) nch_mac l=l_M3 w=w_M3_per_finger*nf_M3 multi=1 nf=nf_M3 sigma=1 mismatchflag=1
    M2 (net20 net48 net19 VSS) nch_mac l=l_M2 w=w_M2_per_finger*nf_M2 multi=1 nf=nf_M2 sigma=1 mismatchflag=1
    M1 (net16 VREF net19 VSS) nch_mac l=l_M1 w=w_M1_per_finger*nf_M1 multi=1 nf=nf_M1 sigma=1 mismatchflag=1
    M0 (VOUT net37 VIN VIN) pch_mac l=l_M0 w=w_M0_per_finger*nf_M0 multi=1 nf=nf_M0 sigma=1 mismatchflag=1
    M18 (net15 net15 VIN VIN) pch_mac l=l_M18 w=w_M18_per_finger*nf_M18 multi=1 nf=nf_M18 sigma=1 mismatchflag=1
    M17 (net27 net15 VIN VIN) pch_mac l=l_M17 w=w_M17_per_finger*nf_M17 multi=1 nf=nf_M17 sigma=1 mismatchflag=1
    M13 (net37 net15 VIN VIN) pch_mac l=l_M13 w=w_M13_per_finger*nf_M13 multi=1 nf=nf_M13 sigma=1 mismatchflag=1
    M10 (net37 net37 VIN VIN) pch_mac l=l_M10 w=w_M10_per_finger*nf_M10 multi=1 nf=nf_M10 sigma=1 mismatchflag=1
    M9 (net34 net50 net37 VIN) pch_mac l=l_M9 w=w_M9_per_finger*nf_M9 multi=1 nf=nf_M9 sigma=1 mismatchflag=1
    M8 (net50 net28 VFB VIN) pch_mac l=l_M8 w=w_M8_per_finger*nf_M8 multi=1 nf=nf_M8 sigma=1 mismatchflag=1
    M7 (net28 net28 net48 VIN) pch_mac l=l_M7 w=w_M7_per_finger*nf_M7 multi=1 nf=nf_M7 sigma=1 mismatchflag=1
    M6 (net48 net16 VIN VIN) pch_mac l=l_M6 w=w_M6_per_finger*nf_M6 multi=1 nf=nf_M6 sigma=1 mismatchflag=1
    M5 (net20 net20 VIN VIN) pch_mac l=l_M5 w=w_M5_per_finger*nf_M5 multi=1 nf=nf_M5 sigma=1 mismatchflag=1
    M4 (net16 net20 VIN VIN) pch_mac l=l_M4 w=w_M4_per_finger*nf_M4 multi=1 nf=nf_M4 sigma=1 mismatchflag=1
    CB (net28 net10) capacitor c=CB
    C1 (net7 net10) capacitor c=C1
    I0 (VIN net7) isource dc=IB type=dc
ends LDO_Core
// LDO_TCASI_Yan/tb_Trans/schematic
I0 (VOUT VIN VOUT VREF VSS) LDO_Core
V2 (VIN 0) vsource dc=1.2 type=dc
V1 (VREF 0) vsource dc=1 type=dc
V0 (VSS 0) vsource dc=0 type=dc
C3 (VOUT VSS) capacitor c=130p
I1 (VOUT VSS) isource dc=10m type=pulse val0=0 val1=10m period=20u delay=5u rise=200.0p fall=200.0p width=5u
simulatorOptions options temp=27
tran tran stop=15u errpreset=conservative
save I1:sink
