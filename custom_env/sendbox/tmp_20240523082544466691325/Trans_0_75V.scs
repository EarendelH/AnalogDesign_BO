// Design: LDO_JSSC2010_Jianping_N65/tb_Trans_0_75V
simulator lang=spectre
global 0
parameters C1=10.75p C2=5.25p CM=6.5p IB=7.75u R1=1900.0k w_M16_per_finger=3.25u l_M16=8.25u nf_M16=1 w_M21_per_finger=9.75u l_M21=0.25u nf_M21=7 w_M24_per_finger=3.25u l_M24=6.25u nf_M24=10 w_M12_per_finger=9.5u l_M12=7.5u nf_M12=3 w_M11_per_finger=9.5u l_M11=7.75u nf_M11=10 w_M5_per_finger=8.25u l_M5=9.25u nf_M5=10 w_M4_per_finger=0.25u l_M4=0.5u nf_M4=10 w_M3_per_finger=0.25u l_M3=0.5u nf_M3=10 w_M33_per_finger=3.25u l_M33=8.5u nf_M33=9 w_M0_per_finger=200.0u l_M0=0.13u nf_M0=20 w_M31_per_finger=10.0u l_M31=10.0u nf_M31=1 w_M32_per_finger=10.0u l_M32=10.0u nf_M32=7 w_M15_per_finger=1.75u l_M15=8.0u nf_M15=10 w_M22_per_finger=8.75u l_M22=0.25u nf_M22=8 w_M23_per_finger=8.75u l_M23=0.25u nf_M23=5 w_M14_per_finger=10.0u l_M14=10.0u nf_M14=10 w_M13_per_finger=10.0u l_M13=10.0u nf_M13=10 w_M6_per_finger=10.0u l_M6=10.0u nf_M6=10 w_M2_per_finger=3.75u l_M2=9.75u nf_M2=9 w_M1_per_finger=3.75u l_M1=9.75u nf_M1=9
include "/home/hanwu/spectre_N65/crn65gplus_2d5_lk_v1d0.scs" section=tt_bip
include "/home/hanwu/spectre_N65/crn65gplus_2d5_lk_v1d0.scs" section=tt_dio
include "/home/hanwu/spectre_N65/crn65gplus_2d5_lk_v1d0.scs" section=tt_dio_33
include "/home/hanwu/spectre_N65/crn65gplus_2d5_lk_v1d0.scs" section=tt_mim
include "/home/hanwu/spectre_N65/crn65gplus_2d5_lk_v1d0.scs" section=tt_dio_dnw
include "/home/hanwu/spectre_N65/crn65gplus_2d5_lk_v1d0.scs" section=tt_dio_18
include "/home/hanwu/spectre_N65/crn65gplus_2d5_lk_v1d0.scs" section=tt_bip_npn
include "/home/hanwu/spectre_N65/crn65gplus_2d5_lk_v1d0.scs" section=tt_33
include "/home/hanwu/spectre_N65/crn65gplus_2d5_lk_v1d0.scs" section=tt_rfrtmom
include "/home/hanwu/spectre_N65/crn65gplus_2d5_lk_v1d0.scs" section=tt_mos_cap_25
include "/home/hanwu/spectre_N65/crn65gplus_2d5_lk_v1d0.scs" section=tt_18
include "/home/hanwu/spectre_N65/crn65gplus_2d5_lk_v1d0.scs" section=tt_disres
include "/home/hanwu/spectre_N65/crn65gplus_2d5_lk_v1d0.scs" section=tt_res
include "/home/hanwu/spectre_N65/crn65gplus_2d5_lk_v1d0.scs" section=tt_dio_na
include "/home/hanwu/spectre_N65/crn65gplus_2d5_lk_v1d0.scs" section=tt_rfmos_33
include "/home/hanwu/spectre_N65/crn65gplus_2d5_lk_v1d0.scs" section=tt_dio_hvt
include "/home/hanwu/spectre_N65/crn65gplus_2d5_lk_v1d0.scs" section=tt_rfmvar
include "/home/hanwu/spectre_N65/crn65gplus_2d5_lk_v1d0.scs" section=tt_rfmos_18
include "/home/hanwu/spectre_N65/crn65gplus_2d5_lk_v1d0.scs" section=tt_na
include "/home/hanwu/spectre_N65/crn65gplus_2d5_lk_v1d0.scs" section=tt_dio_na33
include "/home/hanwu/spectre_N65/crn65gplus_2d5_lk_v1d0.scs" section=tt_dio_lvt
include "/home/hanwu/spectre_N65/crn65gplus_2d5_lk_v1d0.scs" section=tt_rfres_sa
include "/home/hanwu/spectre_N65/crn65gplus_2d5_lk_v1d0.scs" section=tt_na33
include "/home/hanwu/spectre_N65/crn65gplus_2d5_lk_v1d0.scs" section=tt_dio_esd
include "/home/hanwu/spectre_N65/crn65gplus_2d5_lk_v1d0.scs" section=tt_rfmim
include "/home/hanwu/spectre_N65/crn65gplus_2d5_lk_v1d0.scs" section=tt_dio_25od33
include "/home/hanwu/spectre_N65/crn65gplus_2d5_lk_v1d0.scs" section=tt_25od33
include "/home/hanwu/spectre_N65/crn65gplus_2d5_lk_v1d0.scs" section=tt
include "/home/hanwu/spectre_N65/crn65gplus_2d5_lk_v1d0.scs" section=tt_mos_cap
include "/home/hanwu/spectre_N65/crn65gplus_2d5_lk_v1d0.scs" section=tt_dio_25
include "/home/hanwu/spectre_N65/crn65gplus_2d5_lk_v1d0.scs" section=tt_dio_25ud18
include "/home/hanwu/spectre_N65/crn65gplus_2d5_lk_v1d0.scs" section=tt_25
include "/home/hanwu/spectre_N65/crn65gplus_2d5_lk_v1d0.scs" section=tt_rfmos
include "/home/hanwu/spectre_N65/crn65gplus_2d5_lk_v1d0.scs" section=tt_25ud18
include "/home/hanwu/spectre_N65/crn65gplus_2d5_lk_v1d0.scs" section=tt_dio_na25od33
include "/home/hanwu/spectre_N65/crn65gplus_2d5_lk_v1d0.scs" section=tt_rfjvar
include "/home/hanwu/spectre_N65/crn65gplus_2d5_lk_v1d0.scs" section=tt_rfmos_25
include "/home/hanwu/spectre_N65/crn65gplus_2d5_lk_v1d0.scs" section=tt_rtmom
include "/home/hanwu/spectre_N65/crn65gplus_2d5_lk_v1d0.scs" section=tt_na25od33
include "/home/hanwu/spectre_N65/crn65gplus_2d5_lk_v1d0.scs" section=tt_dio_na25
include "/home/hanwu/spectre_N65/crn65gplus_2d5_lk_v1d0.scs" section=tt_rfres_rpo
include "/home/hanwu/spectre_N65/crn65gplus_2d5_lk_v1d0.scs" section=tt_hvt
include "/home/hanwu/spectre_N65/crn65gplus_2d5_lk_v1d0.scs" section=tt_rfind
include "/home/hanwu/spectre_N65/crn65gplus_2d5_lk_v1d0.scs" section=tt_rfmvar_25
include "/home/hanwu/spectre_N65/crn65gplus_2d5_lk_v1d0.scs" section=tt_na25
include "/home/hanwu/spectre_N65/crn65gplus_2d5_lk_v1d0.scs" section=tt_lvt
// LDO_JSSC2010_Jianping_N65/LDO_Core/schematic
subckt LDO_Core VFB VIN VOUT VREF VSS
    M16 (net20 net16 VIN VIN) pch_mac l=l_M16 w=w_M16_per_finger*nf_M16 multi=1 nf=nf_M16 sigma=1 mismatchflag=1
    M21 (net22 net20 VIN VIN) pch_mac l=l_M21 w=w_M21_per_finger*nf_M21 multi=1 nf=nf_M21 sigma=1 mismatchflag=1
    M24 (net26 net16 VIN VIN) pch_mac l=l_M24 w=w_M24_per_finger*nf_M24 multi=1 nf=nf_M24 sigma=1 mismatchflag=1
    M12 (net32 net32 net35 VDD) pch_mac l=l_M12 w=w_M12_per_finger*nf_M12 multi=1 nf=nf_M12 sigma=1 mismatchflag=1
    M11 (net45 net32 VFB VDD) pch_mac l=l_M11 w=w_M11_per_finger*nf_M11 multi=1 nf=nf_M11 sigma=1 mismatchflag=1
    M5 (net35 net37 VIN VIN) pch_mac l=l_M5 w=w_M5_per_finger*nf_M5 multi=1 nf=nf_M5 sigma=1 mismatchflag=1
    M4 (net42 net42 VIN VIN) pch_mac l=l_M4 w=w_M4_per_finger*nf_M4 multi=1 nf=nf_M4 sigma=1 mismatchflag=1
    M3 (net37 net42 VIN VIN) pch_mac l=l_M3 w=w_M3_per_finger*nf_M3 multi=1 nf=nf_M3 sigma=1 mismatchflag=1
    C1 (VFB net9) capacitor c=C1
    C3 (net20 VFB) capacitor c=CM
    C2 (net37 VSS) capacitor c=C2
    R1 (net8 net9) resistor r=R1
    I0 (VIN net8) isource dc=IB type=dc
    M33 (net16 net16 VIN VIN) pch_mac l=l_M33 w=w_M33_per_finger*nf_M33 multi=1 nf=nf_M33 sigma=1 mismatchflag=1
    M0 (VOUT net26 VIN VIN) pch_mac l=l_M0 w=w_M0_per_finger*1 multi=nf_M0 nf=1 sigma=1 mismatchflag=1
    M31 (net8 net8 VSS VSS) nch_mac l=l_M31 w=w_M31_per_finger*nf_M31 multi=1 nf=nf_M31 sigma=1 mismatchflag=1
    M32 (net16 net9 VSS VSS) nch_mac l=l_M32 w=w_M32_per_finger*nf_M32 multi=1 nf=nf_M32 sigma=1 mismatchflag=1
    M15 (net20 VREF net45 VSS) nch_mac l=l_M15 w=w_M15_per_finger*nf_M15 multi=1 nf=nf_M15 sigma=1 mismatchflag=1
    M22 (net22 net22 VSS VSS) nch_mac l=l_M22 w=w_M22_per_finger*nf_M22 multi=1 nf=nf_M22 sigma=1 mismatchflag=1
    M23 (net26 net22 VSS VSS) nch_mac l=l_M23 w=w_M23_per_finger*nf_M23 multi=1 nf=nf_M23 sigma=1 mismatchflag=1
    M14 (net32 net8 VSS VSS) nch_mac l=l_M14 w=w_M14_per_finger*nf_M14 multi=1 nf=nf_M14 sigma=1 mismatchflag=1
    M13 (net45 net8 VSS VSS) nch_mac l=l_M13 w=w_M13_per_finger*nf_M13 multi=1 nf=nf_M13 sigma=1 mismatchflag=1
    M6 (net41 net8 VSS VSS) nch_mac l=l_M6 w=w_M6_per_finger*nf_M6 multi=1 nf=nf_M6 sigma=1 mismatchflag=1
    M2 (net37 VREF net41 VSS) nch_mac l=l_M2 w=w_M2_per_finger*nf_M2 multi=1 nf=nf_M2 sigma=1 mismatchflag=1
    M1 (net42 net35 net41 VSS) nch_mac l=l_M1 w=w_M1_per_finger*nf_M1 multi=1 nf=nf_M1 sigma=1 mismatchflag=1
ends LDO_Core
// LDO_JSSC2010_Jianping_N65/tb_Trans_0_75V/schematic
V2 (VIN 0) vsource dc=750.00m type=dc
V1 (VREF 0) vsource dc=500.0m type=dc
V0 (VSS 0) vsource dc=0 type=dc
I1 (VOUT VSS) isource type=pulse val0=1.5m val1=100m period=10u delay=5u rise=100n fall=100n width=5u
C0 (VOUT VSS) capacitor c=50p
I0 (VOUT VIN VOUT VREF VSS) LDO_Core
simulatorOptions options temp=27
tran tran stop=15u errpreset=conservative
save I1:sink
