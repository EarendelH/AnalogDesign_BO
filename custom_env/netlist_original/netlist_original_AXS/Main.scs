// Design: LDO_AXS/tb_DC
simulator lang=spectre
global 0
parameters DVDD=1.2 i_load=1u VREF=0.5 VDDI=1.65 ESR=3 V1=0 V2=0 V3=1.2 V0=1.2 r_load=1200000 EN=1.65 POC_VDDI=1.65
include "/home/wuhan/Downloads/spectre/HLMC_55HV_MV8V_V1P12_CORNER.LIB" section=TT
include "/home/wuhan/Downloads/spectre/HLMC_55HV_MV8V_V1P12_CORNER.LIB" section=DIO_ALL_TT
include "/home/wuhan/Downloads/spectre/HLMC_55HV_MV8V_V1P12_CORNER.LIB" section=BJT_ALL_TT
include "/home/wuhan/Downloads/spectre/HLMC_55HV_MV8V_V1P12_CORNER.LIB" section=RES_ALL_TT
include "/home/wuhan/Downloads/spectre/HLMC_55HV_MV8V_V1P12_CORNER.LIB" section=VAR_ALL_TT
include "/home/wuhan/Downloads/spectre/HLMC_55HV_MV8V_V1P12_CORNER.LIB" section=MOM_ALL_TT

// AXS3804_ALF_LDO_DVDD_20mA/nmos_bias/schematic
subckt nmos_bias B D G S
    M115 (net6 G net10 B) n8ud33io w=(4u) l=2u nf=1 multi=(1) mismatch=1 global_flag=1
    M114 (net9 G net6 B) n8ud33io w=(4u) l=2u nf=1 multi=(1) mismatch=1 global_flag=1
    M113 (net2 G net9 B) n8ud33io w=(4u) l=2u nf=1 multi=(1) mismatch=1 global_flag=1
    M112 (net8 G net2 B) n8ud33io w=(4u) l=2u nf=1 multi=(1) mismatch=1 global_flag=1
    M111 (net4 G net8 B) n8ud33io w=(4u) l=2u nf=1 multi=(1) mismatch=1 global_flag=1
    M110 (net3 G net4 B) n8ud33io w=(4u) l=2u nf=1 multi=(1) mismatch=1 global_flag=1
    M103 (net20 G net15 B) n8ud33io w=(4u) l=2u nf=1 multi=(1) mismatch=1 global_flag=1
    M104 (net15 G net16 B) n8ud33io w=(4u) l=2u nf=1 multi=(1) mismatch=1 global_flag=1
    M105 (net16 G net14 B) n8ud33io w=(4u) l=2u nf=1 multi=(1) mismatch=1 global_flag=1
    M106 (net14 G net1 B) n8ud33io w=(4u) l=2u nf=1 multi=(1) mismatch=1 global_flag=1
    M107 (net1 G net5 B) n8ud33io w=(4u) l=2u nf=1 multi=(1) mismatch=1 global_flag=1
    M108 (net5 G net7 B) n8ud33io w=(4u) l=2u nf=1 multi=(1) mismatch=1 global_flag=1
    M109 (net7 G net3 B) n8ud33io w=(4u) l=2u nf=1 multi=(1) mismatch=1 global_flag=1
    M116 (net10 G S B) n8ud33io w=(4u) l=2u nf=1 multi=(1) mismatch=1 global_flag=1
    M101 (D G net19 B) n8ud33io w=(4u) l=2u nf=1 multi=(1) mismatch=1 global_flag=1
    M102 (net19 G net20 B) n8ud33io w=(4u) l=2u nf=1 multi=(1) mismatch=1 global_flag=1
ends nmos_bias

// AXS3804_ALF_LDO_DVDD_20mA/pmos_bias/schematic
subckt pmos_bias B D G S
    M201 (net7 G S B) p8ud33io w=(4u) l=2u nf=1 multi=(1) mismatch=1 global_flag=1
    M202 (net8 G net7 B) p8ud33io w=(4u) l=2u nf=1 multi=(1) mismatch=1 global_flag=1
    M203 (net9 G net8 B) p8ud33io w=(4u) l=2u nf=1 multi=(1) mismatch=1 global_flag=1
    M204 (net11 G net9 B) p8ud33io w=(4u) l=2u nf=1 multi=(1) mismatch=1 global_flag=1
    M205 (net10 G net11 B) p8ud33io w=(4u) l=2u nf=1 multi=(1) mismatch=1 global_flag=1
    M206 (D G net10 B) p8ud33io w=(4u) l=2u nf=1 multi=(1) mismatch=1 global_flag=1
ends pmos_bias

// LDO_AXS/LDO_Core/schematic
subckt LDO_Core AVSS AVSS_DC DVDD DVSS IBP_1UA LDO_DVDD_20mA_EN_VDDI LDO_DVDD_20mA_VADJ_DTA\<3\> LDO_DVDD_20mA_VADJ_DTA\<2\> LDO_DVDD_20mA_VADJ_DTA\<1\> LDO_DVDD_20mA_VADJ_DTA\<0\> LOOP_GAIN_A LOOP_GAIN_B LPBGR_0P5V POC_VDDI VDDI VOUT
    I13 (AVSS VBN2 VBN2 AVSS) nmos_bias
    M50 (net4 EN AVSS AVSS) n8ud33io w=(4u) l=800n nf=1 multi=(1) mismatch=1 global_flag=1
    M49 (net1 ENN AVSS AVSS) n8ud33io w=(4u) l=800n nf=1 multi=(25) mismatch=1 global_flag=1
    M36 (net15 VBN1 AVSS AVSS) n8ud33io w=(4u) l=6u nf=1 multi=(2) mismatch=1 global_flag=1
    M35 (net15 net15 AVSS AVSS) n8ud33io w=(4u) l=2u nf=1 multi=(1) mismatch=1 global_flag=1
    M23 (VBP1 net5 AVSS AVSS) n8ud33io w=(2u) l=3u nf=1 multi=(1) mismatch=1 global_flag=1
    M19 (net17 VBN2 net3 AVSS) n8ud33io w=(4u) l=2u nf=1 multi=(2) mismatch=1 global_flag=1
    M47 (net15 ENN AVSS AVSS) n8ud33io w=(4u) l=800n nf=1 multi=(1) mismatch=1 global_flag=1
    M43 (VBN2 ENN AVSS AVSS) n8ud33io w=(4u) l=800n nf=1 multi=(1) mismatch=1 global_flag=1
    M42 (VBN1 ENN AVSS AVSS) n8ud33io w=(4u) l=800n nf=1 multi=(1) mismatch=1 global_flag=1
    M39 (net5 ENN AVSS AVSS) n8ud33io w=(2u) l=800n nf=1 multi=(1) mismatch=1 global_flag=1
    M25 (net3 VBN1 AVSS AVSS) n8ud33io w=(4u) l=6u nf=1 multi=(3) mismatch=1 global_flag=1
    M18 (VBN1 VBN2 net10 AVSS) n8ud33io w=(4u) l=2u nf=1 multi=(1) mismatch=1 global_flag=1
    M20 (net18 VBN2 net7 AVSS) n8ud33io w=(4u) l=2u nf=1 multi=(2) mismatch=1 global_flag=1
    M26 (net7 VBN1 AVSS AVSS) n8ud33io w=(4u) l=6u nf=1 multi=(3) mismatch=1 global_flag=1
    M24 (net10 VBN1 AVSS AVSS) n8ud33io w=(4u) l=6u nf=1 multi=(1) mismatch=1 global_flag=1
    M22 (VBP2 net5 AVSS AVSS) n8ud33io w=(2u) l=3u nf=1 multi=(1) mismatch=1 global_flag=1
    M21 (net5 net5 AVSS AVSS) n8ud33io w=(2u) l=3u nf=1 multi=(1) mismatch=1 global_flag=1
    M28 (net19 net15 AVSS AVSS) n8ud33io w=(4u) l=2u nf=1 multi=(10) mismatch=1 global_flag=1
    M51 (net18 EN VDDI VDDI) p8ud33io w=(6u) l=700n nf=1 multi=(1) mismatch=1 global_flag=1
    M46 (net19 EN VDDI VDDI) p8ud33io w=(2u) l=700n nf=1 multi=(1) mismatch=1 global_flag=1
    M44 (net17 EN VDDI VDDI) p8ud33io w=(6u) l=700n nf=1 multi=(1) mismatch=1 global_flag=1
    M41 (VBP1 EN VDDI VDDI) p8ud33io w=(6u) l=700n nf=1 multi=(1) mismatch=1 global_flag=1
    M40 (VBP2 EN VDDI VDDI) p8ud33io w=(4u) l=700n nf=1 multi=(1) mismatch=1 global_flag=1
    M34 (net15 net18 VDDI VDDI) p8ud33io w=(2u) l=1u nf=1 multi=(4) mismatch=1 global_flag=1
    M10 (VBN2 VBP2 net11 VDDI) p8ud33io w=(4u) l=2u nf=1 multi=(1) mismatch=1 global_flag=1
    M3 (net2 VBP1 VDDI VDDI) p8ud33io w=(6u) l=2u nf=1 multi=(2) mismatch=1 global_flag=1
    M2 (net8 VBP1 VDDI VDDI) p8ud33io w=(6u) l=2u nf=1 multi=(1) mismatch=1 global_flag=1
    M11 (VBN1 VBP2 net8 VDDI) p8ud33io w=(4u) l=2u nf=1 multi=(1) mismatch=1 global_flag=1
    M5 (net18 net17 VDDI VDDI) p8ud33io w=(6u) l=2u nf=1 multi=(2) mismatch=1 global_flag=1
    M9 (VBP1 VBP2 net12 VDDI) p8ud33io w=(4u) l=2u nf=1 multi=(1) mismatch=1 global_flag=1
    M1 (net11 VBP1 VDDI VDDI) p8ud33io w=(6u) l=2u nf=1 multi=(1) mismatch=1 global_flag=1
    M16 (net7 LPBGR_0P5V net2 VDDI) p8ud33io w=(5u) l=1u nf=1 multi=(16) mismatch=1 global_flag=1
    M15 (net3 LOOP_GAIN_B net2 VDDI) p8ud33io w=(5u) l=1u nf=1 multi=(16) mismatch=1 global_flag=1
    M7 (VOUT net19 VDDI VDDI) p8ud33io w=(33u) l=700n nf=1 multi=(120) mismatch=1 global_flag=1
    M6 (net19 net19 VDDI VDDI) p8ud33io w=(2u) l=1u nf=1 multi=(1) mismatch=1 global_flag=1
    M0 (net12 VBP1 VDDI VDDI) p8ud33io w=(6u) l=2u nf=1 multi=(1) mismatch=1 global_flag=1
    M4 (net17 net17 VDDI VDDI) p8ud33io w=(6u) l=2u nf=1 multi=(2) mismatch=1 global_flag=1
    I0 (IBP_1UA VDDI AVSS net5 EN) tg_x1_3p3v
    C0 (net7 VOUT) mom23 lr=5u nf=100 mr=24 mom_mismatch=1
    C2 (VDDI net18) mom23 lr=5u nf=100 mr=9
    I2 (LOOP_GAIN_A AVSS AVSS_DC) RES_FB
    I3 (VOUT AVSS LOOP_GAIN_A RES_ADJ\<3\> RES_ADJ\<2\> RES_ADJ\<1\> RES_ADJ\<0\>) RES_ADJ
    R2 (AVSS net1 VOUT) res_pposab_pcell_1 m=1 segL=5u segW=1u res_mismatch=1 flag_cap=1
    R0 (AVSS net19 VDDI) res_pposab_pcell_2 m=1 segL=8u segW=2u res_mismatch=1 flag_cap=1
    R1 (AVSS net4 VOUT) res_pposab_pcell_3 m=1 segL=5u segW=1u res_mismatch=1 flag_cap=1
    I12 (VDDI AVSS ENN EN) inv_x1_3p3v
    I1 (VDDI AVSS LDO_DVDD_20mA_EN_VDDI ENN) inv_x1_3p3v
    I14 (VDDI VBP2 VBP2 VDDI) pmos_bias
    I8 (AVSS DVDD DVSS LDO_DVDD_20mA_VADJ_DTA\<3\> POC_VDDI VDDI RES_ADJ\<3\>) ls_def1_1p8V
    I9 (AVSS DVDD DVSS LDO_DVDD_20mA_VADJ_DTA\<0\> POC_VDDI VDDI RES_ADJ\<0\>) ls_def1_1p8V
    I11 (AVSS DVDD DVSS LDO_DVDD_20mA_VADJ_DTA\<1\> POC_VDDI VDDI RES_ADJ\<1\>) ls_def0_1p8V
    I10 (AVSS DVDD DVSS LDO_DVDD_20mA_VADJ_DTA\<2\> POC_VDDI VDDI RES_ADJ\<2\>) ls_def0_1p8V
ends LDO_Core

// LDO_AXS/tb_DC/schematic
V17 (DVSS 0) vsource dc=0 type=dc
V16 (DVDD AVSS) vsource dc=DVDD type=dc
V14 (POC_VDDI AVSS) vsource dc=POC_VDDI type=dc
V13 (RES_ADJ\<2\> AVSS) vsource dc=V2 type=dc
V12 (RES_ADJ\<3\> AVSS) vsource dc=V3 type=dc
V11 (RES_ADJ\<1\> AVSS) vsource dc=V1 type=dc
V10 (RES_ADJ\<0\> AVSS) vsource dc=V0 type=dc
V9 (EN AVSS) vsource dc=EN type=dc
V3 (LPBGR_0P5V AVSS) vsource dc=VREF type=dc
V2 (VDDI AVSS) vsource dc=VDDI type=dc
V0 (AVSS 0) vsource dc=0 type=dc
I1 (net23 AVSS) isource dc=1u type=dc
C2 (net7 AVSS) capacitor c=2.2u
R5 (net6 AVSS) resistor r=r_load
R4 (net6 net8) resistor r=3
R3 (net8 net7) resistor r=40m
I4 (AVSS AVSS DVDD DVSS IBP_1uA EN RES_ADJ\<3\> RES_ADJ\<2\> RES_ADJ\<1\> RES_ADJ\<0\> net18 net9 LPBGR_0P5V POC_VDDI VDDI net6) LDO_Core
IPRB0 (net9 net18) iprobe
simulatorOptions options temp=-40.0
dcOp dc
save V2:p
