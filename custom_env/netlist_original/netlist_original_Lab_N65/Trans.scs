// Design: LDO_Lab/tb_Trans
simulator lang=spectre
global 0
parameters CL=300p IBN=1.0u C1 CB CF R1
include "/data/PDK/pdk_installed/hlmc55_hv_6v/pdk/HLMC_HV055GE_MV6V_CDS_OA_V1P1/hlmc55hv/../models/spectre/HLMC_55HV_V1P1_CORNER.LIB" section=TT
include "/data/PDK/pdk_installed/hlmc55_hv_6v/pdk/HLMC_HV055GE_MV6V_CDS_OA_V1P1/hlmc55hv/../models/spectre/HLMC_55HV_V1P1_CORNER.LIB" section=DIO_ALL_TT
include "/data/PDK/pdk_installed/hlmc55_hv_6v/pdk/HLMC_HV055GE_MV6V_CDS_OA_V1P1/hlmc55hv/../models/spectre/HLMC_55HV_V1P1_CORNER.LIB" section=BJT_ALL_TT
include "/data/PDK/pdk_installed/hlmc55_hv_6v/pdk/HLMC_HV055GE_MV6V_CDS_OA_V1P1/hlmc55hv/../models/spectre/HLMC_55HV_V1P1_CORNER.LIB" section=RES_ALL_TT
include "/data/PDK/pdk_installed/hlmc55_hv_6v/pdk/HLMC_HV055GE_MV6V_CDS_OA_V1P1/hlmc55hv/../models/spectre/HLMC_55HV_V1P1_CORNER.LIB" section=VAR_ALL_TT
include "/data/PDK/pdk_installed/hlmc55_hv_6v/pdk/HLMC_HV055GE_MV6V_CDS_OA_V1P1/hlmc55hv/../models/spectre/HLMC_55HV_V1P1_CORNER.LIB" section=MOM_ALL_TT

// LDO_Lab/LDO_Core/schematic
subckt LDO_Core IBN_CORE VF1 VF2 VFB VIN VOUT VREF VSS
    M19 (VF1 VSET VOUT VOUT) plvt12 w=(1u) l=54n nf=1 multi=(1) global_flag=0 flag_cpc=1
    M0 (VOUT VG VIN VIN) plvt12 w=(10u) l=54n nf=10 multi=(1) global_flag=0 flag_cpc=1
    M18 (net04 net04 VIN VIN) p12 w=(1u) l=500n nf=1 multi=(1) global_flag=0 flag_cpc=1
    M17 (VG VG VIN VIN) p12 w=(500n) l=54n nf=1 multi=(1) global_flag=0 flag_cpc=1
    M16 (net042 VF2 VG VG) p12 w=(1u) l=54n nf=1 multi=(1) global_flag=0 flag_cpc=1
    M15 (VG net04 VIN VIN) p12 w=(1u) l=500n nf=1 multi=(1) global_flag=0 flag_cpc=1
    M7 (net073 net073 VIN VIN) p6ud33io w=(1u) l=500n nf=1 multi=(1) global_flag=0
    M8 (V1 net073 VIN VIN) p6ud33io w=(1u) l=500n nf=1 multi=(1) global_flag=0
    M9 (V2 V1 VIN VIN) p6ud33io w=(600n) l=600n nf=1 multi=(1) global_flag=0
    M5 (VSET net073 VIN VIN) p6ud33io w=(1u) l=500n nf=1 multi=(1) global_flag=0
    R1 (net040 IBN_CORE) resistor r=R1
    C1 (VOUT net040) capacitor c=C1
    CL (VOUT VSS) capacitor c=CL
    CB (VSET VSS) capacitor c=CB
    CF (VOUT VF1) capacitor c=CF
    M10 (V1 VFB net060 VSS) n6ud33io w=(600n) l=600n nf=1 multi=(1) global_flag=0
    M6 (net073 VREF net060 VSS) n6ud33io w=(600n) l=600n nf=1 multi=(1) global_flag=0
    M4 (V2 V2 VSS VSS) n6ud33io w=(600n) l=600n nf=1 multi=(1) global_flag=0
    M3 (VSET V2 VSS VSS) n6ud33io w=(600n) l=600n nf=1 multi=(1) global_flag=0
    M1 (net060 IBN_CORE VSS VSS) n6ud33io w=(600n) l=600n nf=1 multi=(1) global_flag=0
    M2 (VG net042 VSS VSS) n6ud33io w=(2u) l=540n nf=1 multi=(1) global_flag=0
    M13 (net04 net040 VSS VSS) n6ud33io w=(600n) l=600n nf=1 multi=(1) global_flag=0
    M12 (net042 IBN_CORE VSS VSS) n6ud33io w=(600n) l=600n nf=1 multi=(1) global_flag=0
    M14 (IBN_CORE IBN_CORE VSS VSS) n6ud33io w=(600n) l=600n nf=1 multi=(1) global_flag=0
    M11 (VF1 IBN_CORE VSS VSS) n6ud33io w=(600n) l=600n nf=1 multi=(1) global_flag=0
ends LDO_Core

// LDO_Lab/tb_Trans/schematic
I0 (IBN_CORE net02 net02 VOUT VIN VOUT VREF VSS) LDO_Core
V3 (net4 0) vsource dc=1.8 type=dc
V2 (VREF 0) vsource dc=1.2 type=dc
V1 (VIN 0) vsource dc=1.8 type=dc
V0 (VSS 0) vsource type=dc
I2 (net4 IBN_CORE) isource dc=IBN type=dc
I1 (VOUT VSS) isource type=pulse val0=500.0u val1=50m period=10u delay=5u rise=2n fall=2n width=5u
simulatorOptions options temp=27
tran tran stop=15u errpreset=conservative
save I1:sink
