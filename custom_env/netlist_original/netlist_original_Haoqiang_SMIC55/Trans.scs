// Design: LDO_Haoqiang/tb_Trans
simulator lang=spectre
global 0
parameters cpp=2p ibias C0 C1 C2 C3 C4 C8 R0
include "/data/PDK/pdk_installed/smic55/smic55ll_ulp_09121825_1P7M_6Ic_1TMc_ALPA1_oa_cds_v1.16_2/smic55ll_121825_1tm/../models/spectre/l0055ll_v1p16_spe.lib" section=tt
include "/data/PDK/pdk_installed/smic55/smic55ll_ulp_09121825_1P7M_6Ic_1TMc_ALPA1_oa_cds_v1.16_2/smic55ll_121825_1tm/../models/spectre/l0055ll_v1p16_spe.lib" section=ldmos_tt
include "/data/PDK/pdk_installed/smic55/smic55ll_ulp_09121825_1P7M_6Ic_1TMc_ALPA1_oa_cds_v1.16_2/smic55ll_121825_1tm/../models/spectre/l0055ll_v1p16_spe.lib" section=bjt_tt
include "/data/PDK/pdk_installed/smic55/smic55ll_ulp_09121825_1P7M_6Ic_1TMc_ALPA1_oa_cds_v1.16_2/smic55ll_121825_1tm/../models/spectre/l0055ll_v1p16_spe.lib" section=dio_tt
include "/data/PDK/pdk_installed/smic55/smic55ll_ulp_09121825_1P7M_6Ic_1TMc_ALPA1_oa_cds_v1.16_2/smic55ll_121825_1tm/../models/spectre/l0055ll_v1p16_spe.lib" section=res_tt
include "/data/PDK/pdk_installed/smic55/smic55ll_ulp_09121825_1P7M_6Ic_1TMc_ALPA1_oa_cds_v1.16_2/smic55ll_121825_1tm/../models/spectre/l0055ll_v1p16_spe.lib" section=var_tt
include "/data/PDK/pdk_installed/smic55/smic55ll_ulp_09121825_1P7M_6Ic_1TMc_ALPA1_oa_cds_v1.16_2/smic55ll_121825_1tm/../models/spectre/l0055ll_v1p16_spe.lib" section=mom_tt

// LDO_Haoqiang/bonding_wire/schematic
subckt bonding_wire VIN VOUT
    L0 (VIN net5) inductor l=1n
    R0 (net5 VOUT) resistor r=50m
ends bonding_wire

// LDO_Haoqiang/LDO_Core/schematic
subckt LDO_Core IBIAS VBODY VF1 VF2 VFB_FFRC VH VIN VOUT VOUT_MIR VREF VSET VSET_FB VSS
    M47 (V2_FFRC net077 VIN VIN) p12ll w=120n l=1u nf=1 m=1
    M46 (net077 net077 VIN VIN) p12ll w=480n l=1u nf=4 m=1
    M42 (net068 net068 VOUT VOUT) p12ll w=120n l=1u nf=1 m=1
    M41 (net069 net068 net0102 net0102) p12ll w=720n l=1u nf=6 m=1
    M27 (net066 net066 VIN VIN) p12ll w=120n l=1u nf=1 m=1
    M26 (VG_FFRC net066 VIN VIN) p12ll w=120n l=1u nf=1 m=1
    M25 (V1_FFRC VG_FFRC VIN VIN) p12ll w=120n l=400n nf=1 m=1
    M24 (V2_FFRC V2_FFRC VIN VIN) p12ll w=120n l=1.4u nf=1 m=1
    M23 (V3_SSF V2_FFRC VBODY VBODY) p12ll w=360n l=100n nf=3 m=1
    M19 (VOUT_MIR VG_VSET VIN VIN) p12ll w=240n l=350n nf=2 m=1
    M22 (VBODY net090 VIN VIN) p12ll w=600n l=1u nf=5 m=1
    M15 (VG_VSET net054 VIN VIN) p12ll w=120n l=500n nf=1 m=1
    M14 (net054 net054 VIN VIN) p12ll w=120n l=500n nf=1 m=1
    M6 (VSET VSET VOUT_MIR VOUT_MIR) p12ll w=120n l=300n nf=1 m=1
    M21 (net090 net090 VIN VIN) p12ll w=120n l=1u nf=1 m=1
    M1 (VF1 VSET VOUT VOUT) p12ll w=480n l=300n nf=4 m=1
    M36 (net092 IBIAS VSS VSS) n25ll w=210n l=1u nf=1 m=1
    M35 (net067 IB_FFRC VSS VSS) n25ll w=420n l=1u nf=2 m=1
    M34 (net090 IB_FFRC VSS VSS) n25ll w=420n l=1u nf=2 m=1
    M13 (V3_SSF IB_FFRC VSS VSS) n25ll w=1.05u l=1u nf=5 m=1
    M33 (IB_FFRC IB_FFRC VSS VSS) n25ll w=210n l=1u nf=1 m=1
    M32 (VG_FFRC VFB_FFRC net067 VSS) n25ll w=420n l=2u nf=2 m=1
    M31 (net066 VREF net067 VSS) n25ll w=420n l=2u nf=2 m=1
    M20 (net053 IBIAS VSS VSS) n25ll w=420n l=1u nf=2 m=1
    M18 (VSET IBIAS VSS VSS) n25ll w=210n l=1u nf=1 m=1
    M11 (IBIAS IBIAS VSS VSS) n25ll w=210n l=1u nf=1 m=1
    M10 (net25 IBIAS VSS VSS) n25ll w=210n l=1u nf=1 m=1
    M8 (VF3 VREF VF2 VSS) n25ll w=210n l=280n nf=1 m=1
    M7 (VF2 IBIAS VSS VSS) n25ll w=840n l=1u nf=4 m=1
    M12 (VG VF2 VSS VSS) n25ll w=210n l=280n nf=1 m=1
    M4 (VG IBIAS VSS VSS) n25ll w=420n l=1u nf=2 m=1
    M2 (VF1 IBIAS VSS VSS) n25ll w=840n l=1u nf=4 m=1
    R0 (VG net43) resistor r=R0
    C8 (V2_FFRC VSS) capacitor c=C8
    C4 (VG_FFRC VSS) capacitor c=C4
    C2 (VOUT_MIR VSS) capacitor c=C2
    C3 (VSET VSS) capacitor c=C3
    C0 (net43 VSS) capacitor c=C0
    C1 (VIN V1_FFRC) capacitor c=C1
    M40 (VIN VG net0102 net0102) nlvt12ll w=120n l=60n nf=1 m=1
    M0 (VIN VG VOUT VBODY) nlvt12ll_power w=1.8u l=60n nf=15 m=20
    M38 (IB_FFRC net092 VIN VIN) p25ll w=210n l=500n nf=1 m=1
    M37 (net092 net092 VIN VIN) p25ll w=210n l=500n nf=1 m=1
    M9 (net25 net25 VH VH) p25ll w=210n l=500n nf=1 m=1
    M5 (VG VF3 VH VH) p25ll w=210n l=280n nf=1 m=1
    M3 (VF3 net25 VH VH) p25ll w=840n l=500n nf=4 m=1
    M43 (net068 net069 VSS VSS) n12ll w=120n l=1u nf=1 m=1
    M44 (net069 net069 VSS VSS) n12ll w=720n l=1u nf=6 m=1
    M30 (V1_FFRC V1_FFRC VSS VSS) n12ll w=120n l=400n nf=1 m=1
    M29 (V2_FFRC V1_FFRC VSS VSS) n12ll w=120n l=400n nf=1 m=1
    M28 (VBODY V3_SSF VSS VSS) n12ll w=120n l=60n nf=1 m=1
    M17 (VG_VSET VREF net053 VSS) n12ll w=120n l=800n nf=1 m=1
    M16 (net054 VSET_FB net053 VSS) n12ll w=120n l=800n nf=1 m=1
    M45 (net077 net069 VSS VSS) n12ll w=120n l=1u nf=1 m=1
ends LDO_Core

// LDO_Haoqiang/probe/schematic
subckt probe VIN VSS
    C0 (VIN VSS) capacitor c=10p
    R0 (VIN VSS) resistor r=1M
ends probe

// LDO_Haoqiang/tb_Trans/schematic
I5 (VOUT_IS VOUT_OS) bonding_wire
V4 (VSS 0) vsource dc=0 type=dc
V3 (VH VSS) vsource dc=2 type=dc
V1 (VREF VSS) vsource dc=1 type=dc
V0 (VIN VSS) vsource dc=1.2 type=dc
I2 (VIN net6) isource dc=ibias type=dc
R0 (net014 VOUT_IS) resistor r=0
C0 (VOUT_IS VSS) capacitor c=cpp
I10 (net6 VBODY VFB_MIAN VFB_MIAN VBODY VH VIN net014 VFB_VSET VREF VSET VFB_VSET VSS) LDO_Core
I4 (VOUT_IS VSS) isource type=pwl wave=[ 2u 200u 2.01u 50m 7u 50m 7.01u 200u ]
I6 (VOUT_OS VSS) probe
simulatorOptions options temp=27
tran tran stop=10u errpreset=conservative
save R0:1 I10.M5:3 I10.M12:1
