// Design: Buck_Simple/tb_Efficiency
simulator lang=spectre
global 0
parameters ILOAD=1
include "/data/PDK/pdk_installed/tsmc180bcd_g2/pdk/pdk_1p6m/tsmc18/../models/spectre/c018bcd_gen2_v1d6_usage.scs" section=pre_simu
include "/data/PDK/pdk_installed/tsmc180bcd_g2/pdk/pdk_1p6m/tsmc18/../models/spectre/c018bcd_gen2_v1d6_usage.scs" section=tt_lib

// Buck_Simple/driver_s2/schematic
subckt driver_s2 IN OUT VDD VSS
    M45 (OUT net028 VDD VDD) pch_5_mac_multi l=500n w=50u multi=100 nf=1 sigma=1 mismatchflag=1
    M46 (net028 net026 VDD VDD) pch_5_mac_multi l=500n w=3u multi=100 nf=1 sigma=1 mismatchflag=1
    M47 (net026 net024 VDD VDD) pch_5_mac_multi l=500n w=3u multi=10 nf=1 sigma=1 mismatchflag=1
    M48 (net024 IN VDD VDD) pch_5_mac_multi l=500n w=1u multi=10 nf=1 sigma=1 mismatchflag=1
    M41 (OUT net028 VSS VSS) nch_5_mac_multi l=600n w=50u multi=100 nf=1 sigma=1 mismatchflag=1
    M42 (net028 net026 VSS VSS) nch_5_mac_multi l=600n w=3u multi=100 nf=1 sigma=1 mismatchflag=1
    M43 (net026 net024 VSS VSS) nch_5_mac_multi l=600n w=3u multi=10 nf=1 sigma=1 mismatchflag=1
    M44 (net024 IN VSS VSS) nch_5_mac_multi l=600n w=1u multi=10 nf=1 sigma=1 mismatchflag=1
ends driver_s2

// Buck_Simple/driver_s1/schematic
subckt driver_s1 IN OUT VDD VSS
    M31 (OUT net16 VDD VDD) pch_5_mac_multi l=500n w=50u multi=100 nf=1 sigma=1 mismatchflag=1
    M33 (net16 net14 VDD VDD) pch_5_mac_multi l=500n w=3u multi=100 nf=1 sigma=1 mismatchflag=1
    M37 (net14 net13 VDD VDD) pch_5_mac_multi l=500n w=3u multi=10 nf=1 sigma=1 mismatchflag=1
    M38 (net13 IN VDD VDD) pch_5_mac_multi l=500n w=1u multi=10 nf=1 sigma=1 mismatchflag=1
    M32 (OUT net16 VSS VSS) nch_5_mac_multi l=600n w=50u multi=100 nf=1 sigma=1 mismatchflag=1
    M34 (net16 net14 VSS VSS) nch_5_mac_multi l=600n w=3u multi=100 nf=1 sigma=1 mismatchflag=1
    M35 (net14 net13 VSS VSS) nch_5_mac_multi l=600n w=3u multi=10 nf=1 sigma=1 mismatchflag=1
    M36 (net13 IN VSS VSS) nch_5_mac_multi l=600n w=1u multi=10 nf=1 sigma=1 mismatchflag=1
ends driver_s1

// Buck_Simple/Buck_Core/schematic
subckt Buck_Core GND VCH VCL VIN VOUT
    I1 (VCL VGL VIN GND) driver_s2
    M2 (SW VGL GND GND) nch_5_mac l=600n w=1.000m multi=100 nf=10 sigma=1 mismatchflag=1
    M1 (VIN VGH SW SW) nch_5_mac l=600n w=1.000m multi=100 nf=10 sigma=1 mismatchflag=1
    I0 (VCH_LS VGH VBST SW) driver_s1
    C1 (VBST SW) capacitor c=1n
    L0 (SW VOUT) inductor l=240.00n r=25m
    E0 (VCH_LS SW VCH GND) vcvs gain=1.0
    D2 (VIN VBST GND) sbd_dio_ga_12_3t dti=0 multi=20
ends Buck_Core

// Buck_Simple/tb_Efficiency/schematic
C0 (VOUT net010) capacitor c=22u
R0 (net010 GND) resistor r=4m
I11 (GND VCH VCL VIN VOUT) Buck_Core
V0 (VIN 0) vsource dc=3.3 type=dc
V1 (GND 0) vsource dc=0 type=dc
V3 (VCL 0) vsource dc=0 type=pulse val0=3.3 val1=0 period=250.00n rise=1n fall=1n width=75n
V2 (VCH 0) vsource dc=0 type=pulse val0=0 val1=3.3 period=250.00n delay=3n rise=1n fall=1n width=69n
I6 (VOUT GND) isource dc=ILOAD type=dc
simulatorOptions options temp=27
tran tran stop=60u errpreset=conservative cmin=10a
save V0:p
