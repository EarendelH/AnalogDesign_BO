// Design: Buck/tb
simulator lang=spectre
global 0
parameters T_INTEG=10u ILOAD=1.5 T_TRAN=60u CBST=0.5p COUT=22u D=0.3 DCR=25m ESR=4m fsw=4M VIN=3.3 L=0.24u N2=140 N1=100
include "/data/PDK/pdk_installed/tsmc180bcd_g2/pdk/pdk_1p6m/tsmc18/../models/spectre/c018bcd_gen2_v1d6_usage.scs" section=pre_simu
include "/data/PDK/pdk_installed/tsmc180bcd_g2/pdk/pdk_1p6m/tsmc18/../models/spectre/c018bcd_gen2_v1d6_usage.scs" section=tt_lib

// Buck/driver_s2/schematic
subckt driver_s2 IN OUT VDD VSS
    M45 (OUT net028 VDD VDD) pch_5_mac l=500n w=50u multi=N2 nf=1 sigma=1 mismatchflag=1
    M46 (net028 net026 VDD VDD) pch_5_mac l=500n w=3u multi=N2 nf=1 sigma=1 mismatchflag=1
    M47 (net026 net024 VDD VDD) pch_5_mac l=500n w=3u multi=0.1*N2 nf=1 sigma=1 mismatchflag=1
    M48 (net024 IN VDD VDD) pch_5_mac l=500n w=1u multi=0.1*N2 nf=1 sigma=1 mismatchflag=1
    M41 (OUT net028 VSS VSS) nch_5_mac l=600n w=50u multi=N2 nf=1 sigma=1 mismatchflag=1
    M42 (net028 net026 VSS VSS) nch_5_mac l=600n w=3u multi=N2 nf=1 sigma=1 mismatchflag=1
    M43 (net026 net024 VSS VSS) nch_5_mac l=600n w=3u multi=0.1*N2 nf=1 sigma=1 mismatchflag=1
    M44 (net024 IN VSS VSS) nch_5_mac l=600n w=1u multi=0.1*N2 nf=1 sigma=1 mismatchflag=1
ends driver_s2

// tsmc18_stdc_5v/DEL4/schematic
subckt DEL4 I Z VDD VSS
    MI4\-M_u3 (net33 net45 VDD VDD) pch_5 l=1.09u w=420.0n m=1 nf=1
    MI8\-M_u3 (net11 net33 VDD VDD) pch_5 l=1.09u w=420.0n m=1 nf=1
    MI3\-M_u3 (Z net9 VDD VDD) pch_5 l=500n w=1.62u m=1 nf=1
    MI7\-M_u3 (net9 net11 VDD VDD) pch_5 l=1.09u w=420.0n m=1 nf=1
    MI6\-M_u3 (net5 I VDD VDD) pch_5 l=500n w=1.62u m=1 nf=1
    MI5\-M_u3 (net45 net5 VDD VDD) pch_5 l=1.09u w=420.0n m=1 nf=1
    MI5\-M_u2 (net45 net5 VSS VSS) nch_5 l=1.09u w=1.26u m=1 nf=1
    MI8\-M_u2 (net11 net33 VSS VSS) nch_5 l=1.09u w=420.0n m=1 nf=1
    MI3\-M_u2 (Z net9 VSS VSS) nch_5 l=600n w=1.26u m=1 nf=1
    MI4\-M_u2 (net33 net45 VSS VSS) nch_5 l=1.09u w=420.0n m=1 nf=1
    MI6\-M_u2 (net5 I VSS VSS) nch_5 l=600n w=1.26u m=1 nf=1
    MI7\-M_u2 (net9 net11 VSS VSS) nch_5 l=1.09u w=1.26u m=1 nf=1
ends DEL4

// tsmc18_stdc_5v/INVD0/schematic
subckt INVD0 I ZN VDD VSS
    MU1\-M_u2 (ZN I VSS VSS) nch_5 l=600n w=630.0n m=1 nf=1
    MU1\-M_u3 (ZN I VDD VDD) pch_5 l=500n w=810.0n m=1 nf=1
ends INVD0

// tsmc18_stdc_5v/BUFFD0/schematic
subckt BUFFD0 I Z VDD VSS
    MI2\-M_u3 (net5 I VDD VDD) pch_5 l=500n w=810.0n m=1 nf=1
    MI1\-M_u3 (Z net5 VDD VDD) pch_5 l=500n w=810.0n m=1 nf=1
    MI2\-M_u2 (net5 I VSS VSS) nch_5 l=600n w=630.0n m=1 nf=1
    MI1\-M_u2 (Z net5 VSS VSS) nch_5 l=600n w=630.0n m=1 nf=1
ends BUFFD0

// Buck/deadtime/schematic
subckt deadtime IN OUT1 OUT2 VDD VSS
    M15 (net09 net28 net24 net24) pch_5_mac l=500n w=2u multi=1 nf=1 sigma=1 mismatchflag=1
    M14 (net24 IN VDD VDD) pch_5_mac l=500n w=2u multi=1 nf=1 sigma=1 mismatchflag=1
    M11 (net010 IN VDD VDD) pch_5_mac l=500n w=2u multi=1 nf=1 sigma=1 mismatchflag=1
    I9 (net36 net34 VDD VSS) DEL4
    I47 (IN net36 VDD VSS) DEL4
    I8 (net35 net28 VDD VSS) DEL4
    I50 (IN net35 VDD VSS) DEL4
    I0 (net010 OUT1 VDD VSS) INVD0
    I1 (net09 OUT2 VDD VSS) BUFFD0
    M16 (net09 IN VSS VSS) nch_5_mac l=600n w=2u multi=1 nf=1 sigma=1 mismatchflag=1
    M13 (net21 IN VSS VSS) nch_5_mac l=600n w=2u multi=1 nf=1 sigma=1 mismatchflag=1
    M12 (net010 net34 net21 net21) nch_5_mac l=600n w=2u multi=1 nf=1 sigma=1 mismatchflag=1
ends deadtime

// Buck/driver_s1/schematic
subckt driver_s1 IN OUT VDD VSS
    M31 (OUT net16 VDD VDD) pch_5_mac l=500n w=50u multi=N1 nf=1 sigma=1 mismatchflag=1
    M33 (net16 net14 VDD VDD) pch_5_mac l=500n w=3u multi=N1 nf=1 sigma=1 mismatchflag=1
    M37 (net14 net13 VDD VDD) pch_5_mac l=500n w=3u multi=0.1*N1 nf=1 sigma=1 mismatchflag=1
    M38 (net13 IN VDD VDD) pch_5_mac l=500n w=1u multi=0.1*N1 nf=1 sigma=1 mismatchflag=1
    M32 (OUT net16 VSS VSS) nch_5_mac l=600n w=50u multi=N1 nf=1 sigma=1 mismatchflag=1
    M34 (net16 net14 VSS VSS) nch_5_mac l=600n w=3u multi=N1 nf=1 sigma=1 mismatchflag=1
    M35 (net14 net13 VSS VSS) nch_5_mac l=600n w=3u multi=0.1*N1 nf=1 sigma=1 mismatchflag=1
    M36 (net13 IN VSS VSS) nch_5_mac l=600n w=1u multi=0.1*N1 nf=1 sigma=1 mismatchflag=1
ends driver_s1

// tsmc18_stdc_5v/INVD1/schematic
subckt INVD1 I ZN VDD VSS
    MU1\-M_u2 (ZN I VSS VSS) nch_5 l=600n w=1.26u m=1 nf=1
    MU1\-M_u3 (ZN I VDD VDD) pch_5 l=500n w=1.62u m=1 nf=1
ends INVD1

// Buck/level_shifter/schematic
subckt level_shifter IN OUT VDDH VDDL VSSH VSSL
    M23 (VSM VS VDDH VDDH) pch_5_mac l=500n w=2u multi=1 nf=1 sigma=1 mismatchflag=1
    M24 (VS VSM VDDH VDDH) pch_5_mac l=500n w=2u multi=1 nf=1 sigma=1 mismatchflag=1
    M27 (VD VSSH VS VS) pch_5_mac l=500n w=10u multi=1 nf=1 sigma=1 mismatchflag=1
    M28 (VDM VSSH VSM VSM) pch_5_mac l=500n w=10u multi=1 nf=1 sigma=1 mismatchflag=1
    I3 (VS OUT VDDH VSSH) INVD1
    I2 (IN net11 VDDL VSSL) INVD1
    I1 (net11 net12 VDDL VSSL) INVD1
    I0 (IN net13 VDDL VSSL) INVD1
    M21 (VD net12 VSSL VSSL) nch_5_mac l=600n w=4u multi=1 nf=1 sigma=1 mismatchflag=1
    M22 (VDM net13 VSSL VSSL) nch_5_mac l=600n w=4u multi=1 nf=1 sigma=1 mismatchflag=1
    M25 (VS VSSH VSSH VSSH) nch_5_mac l=600n w=4u multi=1 nf=1 sigma=1 mismatchflag=1
    M26 (VSM VSSH VSSH VSSH) nch_5_mac l=600n w=4u multi=1 nf=1 sigma=1 mismatchflag=1
ends level_shifter

// Buck/Buck_Core/schematic
subckt Buck_Core GND VC VIN VOUT
    I1 (VCL VGL VIN GND) driver_s2
    M2 (SW VGL GND GND) nch_5_mac l=600n w=1.000m multi=N2 nf=10 sigma=1 mismatchflag=1
    M1 (VIN VGH SW SW) nch_5_mac l=600n w=1.000m multi=N1 nf=10 sigma=1 mismatchflag=1
    I3 (VC VCH VCL VIN GND) deadtime
    C1 (VBST SW) capacitor c=CBST
    L0 (SW VOUT) inductor l=L r=DCR
    I0 (VCH_LS VGH VBST SW) driver_s1
    I10 (VCH VCH_LS VBST VIN SW GND) level_shifter
    D2 (VIN VBST GND) sbd_dio_ga_12_3t dti=0 multi=20
ends Buck_Core

// Buck/tb/schematic
I11 (GND VC VIN VOUT) Buck_Core
C0 (VOUT net010) capacitor c=COUT
R0 (net010 GND) resistor r=ESR
V0 (VIN 0) vsource dc=VIN type=dc
V1 (GND 0) vsource dc=0 type=dc
V2 (VC 0) vsource dc=0 type=pulse val0=0 val1=VIN period=1/fsw rise=1n fall=1n width=D*1/fsw
I6 (VOUT GND) isource dc=ILOAD type=dc
simulatorOptions options temp=27
tran tran stop=T_TRAN errpreset=conservative cmin=10a
save V0:p
