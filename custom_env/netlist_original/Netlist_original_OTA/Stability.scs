// Design: FOLDED_CASCODE/tb_stability
simulator lang=spectre
global 0
parameters R1 R2 IB
include "/pdk/tsmc180bcd_g2/pdk/pdk_1p6m/models/spectre/c018bcd_gen2_v1d6_usage.scs" section=pre_simu
include "/pdk/tsmc180bcd_g2/pdk/pdk_1p6m/models/spectre/c018bcd_gen2_v1d6_usage.scs" section=tt_lib

// FOLDED_CASCODE/OPP/schematic
subckt OPP INN INP VDD VOUT VSS
    M22 (net040 net032 VDD VDD) pch_mac l=5u w=1u multi=1 nf=1 sigma=1 mismatchflag=1
    M23 (net032 net010 net040 VDD) pch_mac l=500n w=5u multi=1 nf=1 sigma=1 mismatchflag=1
    M7 (VOUT net010 net26 VDD) pch_mac l=500n w=5u multi=1 nf=1 sigma=1 mismatchflag=1
    M6 (net018 net010 net28 VDD) pch_mac l=500n w=5u multi=1 nf=1 sigma=1 mismatchflag=1
    M4 (net28 net032 VDD VDD) pch_mac l=5u w=1u multi=1 nf=1 sigma=1 mismatchflag=1
    M5 (net26 net032 VDD VDD) pch_mac l=5u w=1u multi=1 nf=1 sigma=1 mismatchflag=1
    M21 (net039 net039 VSS VSS) nch_mac l=12.0u w=1u multi=1 nf=1 sigma=1 mismatchflag=1
    M24 (net010 net039 VSS VSS) nch_mac l=12.0u w=1u multi=1 nf=1 sigma=1 mismatchflag=1
    M3 (net18 net039 VSS VSS) nch_mac l=12.0u w=1u multi=1 nf=1 sigma=1 mismatchflag=1
    M1 (net28 INP net18 VSS) nch_mac l=1u w=10u multi=1 nf=2 sigma=1 mismatchflag=1
    M2 (net26 INN net18 VSS) nch_mac l=1u w=10u multi=1 nf=2 sigma=1 mismatchflag=1
    M11 (net035 net022 VSS VSS) nch_mac l=10u w=1u multi=1 nf=1 sigma=1 mismatchflag=1
    M10 (net036 net022 VSS VSS) nch_mac l=10u w=1u multi=1 nf=1 sigma=1 mismatchflag=1
    M8 (net022 net018 net036 VSS) nch_mac l=500n w=5u multi=1 nf=1 sigma=1 mismatchflag=1
    M9 (VOUT net018 net035 VSS) nch_mac l=500n w=5u multi=1 nf=1 sigma=1 mismatchflag=1
    IB (VDD net039) isource dc=IB type=dc
    R1 (net032 net010) resistor r=R1
    R2 (net018 net022) resistor r=R2
ends OPP

// FOLDED_CASCODE/tb_stability/schematic
C1 (net3 0) capacitor c=1p
V4 (net4 0) vsource dc=900.0m mag=1 type=sine freq=1M
IPRB1 (Out net3) iprobe
V1 (net2 0) vsource dc=1.8 type=dc
I9 (net3 net4 net2 Out 0) OPP
simulatorOptions options temp=27
dcOp dc
stb stb start=1 stop=1G probe=IPRB1 localgnd=0
