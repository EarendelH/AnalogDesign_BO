// Design: DRMOS_Opt/Efficiency
simulator lang=spectre
global 0
parameters C_BST_CHIP=7n cbst=100n cdrv=3n CIN_CHIP=5n DT_H=1.65n DT_L=2.3n DUTY=0.152 fsw=4M ILOAD=12.5 RBST_CHIP=100m RCIN_CHIP=100m VDRV=2.5 VIN=7.6
include "/data/PDK/pdk_installed/unt55bcd/pdk_current/models/spe/unt_55bcd20_v0p5_usage_spe.lib" section=tt

// DRMOS_Opt/0402_2p2uF_GRM155D71C225ME11_DC0V_25degC/schematic
subckt DRMOS_Opt_0402_2p2uF_GRM155D71C225ME11_DC0V_25degC_schematic port1 port2
    L2 (11 12) inductor l=120.0p
    L9 (18 19) inductor l=29.2p
    L10 (19 20) inductor l=178.00p
    L11 (20 21) inductor l=35.2p
    L12 (21 22) inductor l=30.9p
    L13 (22 port2) inductor l=64.8p
    R3 (12 13) resistor r=5.64m
    R100 (port1 11) resistor r=22.7M
    R4 (13 14) resistor r=266
    R5 (14 15) resistor r=5.19
    R6 (15 16) resistor r=541.000m
    R7 (16 17) resistor r=67.5m
    R8 (17 18) resistor r=10.2m
    R9 (18 19) resistor r=71.5m
    R10 (19 20) resistor r=26.8m
    R11 (20 21) resistor r=3.04m
    R12 (21 22) resistor r=3.44m
    R13 (22 port2) resistor r=11.6
    C1 (port1 11) capacitor c=1.71u
    C4 (13 14) capacitor c=25.7u
    C5 (14 15) capacitor c=77.3u
    C6 (15 16) capacitor c=73.0u
    C7 (16 17) capacitor c=58.8u
    C8 (17 18) capacitor c=40u
    C11 (20 21) capacitor c=5.41u
    C12 (21 22) capacitor c=3.21u
    C13 (22 port2) capacitor c=2.57p
ends DRMOS_Opt_0402_2p2uF_GRM155D71C225ME11_DC0V_25degC_schematic

// DRMOS_Opt/0201_22nF_GRM033R61A223KE84_DC0V_25degC/schematic
subckt DRMOS_Opt_0201_22nF_GRM033R61A223KE84_DC0V_25degC_schematic port1 port2
    C1 (port1 11) capacitor c=22.4n
    C4 (13 14) capacitor c=1.31e-06
    C5 (14 15) capacitor c=2.76e-06
    C6 (15 16) capacitor c=2.74e-06
    C7 (16 17) capacitor c=4.32e-06
    C8 (17 18) capacitor c=3.2e-06
    C9 (18 19) capacitor c=2.7e-06
    C10 (19 20) capacitor c=2.99e-06
    C11 (20 21) capacitor c=2.21e-06
    C13 (22 23) capacitor c=27.5n
    C14 (23 port2) capacitor c=1.06e-12
    L2 (11 12) inductor l=1.84e-10
    L12 (21 22) inductor l=49.5p
    L13 (22 23) inductor l=25.7p
    L14 (23 port2) inductor l=25.5p
    R3 (12 13) resistor r=36.3m
    R100 (port1 11) resistor r=2000000000
    R4 (13 14) resistor r=2610
    R5 (14 15) resistor r=177
    R6 (15 16) resistor r=30.7
    R7 (16 17) resistor r=3.07
    R8 (17 18) resistor r=0.765
    R9 (18 19) resistor r=0.124
    R10 (19 20) resistor r=0.033
    R11 (20 21) resistor r=11.1m
    R12 (21 22) resistor r=0.141
    R13 (22 23) resistor r=34.4m
    R14 (23 port2) resistor r=2.22
ends DRMOS_Opt_0201_22nF_GRM033R61A223KE84_DC0V_25degC_schematic

// DRMOS_Opt/Efficiency/schematic
C_BUMP3_5 (VIN_BUMP VSS_BUMP) DRMOS_Opt_0402_2p2uF_GRM155D71C225ME11_DC0V_25degC_schematic
C_BUMP3_6 (VIN_BUMP VSS_BUMP) DRMOS_Opt_0402_2p2uF_GRM155D71C225ME11_DC0V_25degC_schematic
C_BUMP3_4 (VIN_BUMP VSS_BUMP) DRMOS_Opt_0402_2p2uF_GRM155D71C225ME11_DC0V_25degC_schematic
C_BUMP3_3 (VIN_BUMP VSS_BUMP) DRMOS_Opt_0402_2p2uF_GRM155D71C225ME11_DC0V_25degC_schematic
C_BUMP3_2 (VIN_BUMP VSS_BUMP) DRMOS_Opt_0402_2p2uF_GRM155D71C225ME11_DC0V_25degC_schematic
C_BUMP4_2 (VIN_BUMP VSS_BUMP) DRMOS_Opt_0402_2p2uF_GRM155D71C225ME11_DC0V_25degC_schematic
C_BUMP4_3 (VIN_BUMP VSS_BUMP) DRMOS_Opt_0402_2p2uF_GRM155D71C225ME11_DC0V_25degC_schematic
C_BUMP1_5 (VIN_BUMP VSS_BUMP) DRMOS_Opt_0402_2p2uF_GRM155D71C225ME11_DC0V_25degC_schematic
C_BUMP1_6 (VIN_BUMP VSS_BUMP) DRMOS_Opt_0402_2p2uF_GRM155D71C225ME11_DC0V_25degC_schematic
C_BUMP2_5 (VIN_BUMP VSS_BUMP) DRMOS_Opt_0402_2p2uF_GRM155D71C225ME11_DC0V_25degC_schematic
C_BUMP1_4 (VIN_BUMP VSS_BUMP) DRMOS_Opt_0402_2p2uF_GRM155D71C225ME11_DC0V_25degC_schematic
C_BUMP1_3 (VIN_BUMP VSS_BUMP) DRMOS_Opt_0402_2p2uF_GRM155D71C225ME11_DC0V_25degC_schematic
C_BUMP1_2 (VIN_BUMP VSS_BUMP) DRMOS_Opt_0402_2p2uF_GRM155D71C225ME11_DC0V_25degC_schematic
C_BUMP2_6 (VIN_BUMP VSS_BUMP) DRMOS_Opt_0402_2p2uF_GRM155D71C225ME11_DC0V_25degC_schematic
C_BUMP2_4 (VIN_BUMP VSS_BUMP) DRMOS_Opt_0402_2p2uF_GRM155D71C225ME11_DC0V_25degC_schematic
C_BUMP2_3 (VIN_BUMP VSS_BUMP) DRMOS_Opt_0402_2p2uF_GRM155D71C225ME11_DC0V_25degC_schematic
C_BUMP2_2 (VIN_BUMP VSS_BUMP) DRMOS_Opt_0402_2p2uF_GRM155D71C225ME11_DC0V_25degC_schematic
C_BUMP4_4 (VIN_BUMP VSS_BUMP) DRMOS_Opt_0402_2p2uF_GRM155D71C225ME11_DC0V_25degC_schematic
C_BUMP4_6 (VIN_BUMP VSS_BUMP) DRMOS_Opt_0402_2p2uF_GRM155D71C225ME11_DC0V_25degC_schematic
C_BUMP4_5 (VIN_BUMP VSS_BUMP) DRMOS_Opt_0402_2p2uF_GRM155D71C225ME11_DC0V_25degC_schematic
C_BST_CHIP (BST net0137) capacitor c=C_BST_CHIP
C_BST_BOARD (BST_BUMP SW_BUMP) capacitor c=cbst
C_POL (net011 VSS_POL) capacitor c=28.2u ic=0
CIN_CHIP (VIN_CHIP net0121) capacitor c=CIN_CHIP
C_DRV (VDRV_CHIP VSS_CHIP) capacitor c=cdrv
E8 (VGBST_DIF 0 VGBST BST_BUMP) vcvs gain=1.0
E7 (CBST_DIFF 0 BST_BUMP SW_BUMP) vcvs gain=1.0
E6 (LSG_DIF 0 LSG LSS) vcvs gain=1.0
E4 (VIN_CHIP_DIFF 0 VIN_CHIP VSS_CHIP) vcvs gain=1.0
E2 (VIN_BUMP_DIFF 0 VIN_BUMP VSS_BUMP) vcvs gain=1.0
E3 (VOUT_POL_DIFF 0 VOUT_POL VSS_POL) vcvs gain=1.0
E5 (HSG_DIF 0 HSG HSS) vcvs gain=1.0
E1 (HS_VDS 0 HSD HSS) vcvs gain=1.0
E0 (SW_DIFF 0 SW_IDEAL VSS_CHIP) vcvs gain=1.0
E9 (VBST_DIFF 0 BST SW_IDEAL) vcvs gain=1.0
VS_LSG_IDEAL (LSG_IDEAL VSS_CHIP) vsource type=pulse val0=0 val1=VDRV period=1/fsw delay=DUTY/fsw+DT_H+100p+100p+DT_L rise=100p fall=100p width=1/fsw-DUTY/fsw-DT_H-DT_L-100p-100p-100p-100p
VS_BST1 (BST_BUMP VGBST) vsource type=pulse val0=0 val1=VDRV period=1/fsw delay=DUTY/fsw+DT_H+100p+100p+DT_L+10n rise=1n fall=1n width=1/fsw-DUTY/fsw-DT_H-15n
VS_HSG_IDEAL (HSG_IDEAL SW_IDEAL) vsource type=pulse val0=0 val1=VDRV period=1/fsw delay=DT_H rise=100p fall=100p width=DUTY/fsw
VS_BST2 (VGBST2 VSS_CHIP) vsource type=pulse val0=VDRV val1=0 period=1/fsw delay=DUTY/fsw+DT_H+100p+100p+DT_L+10n rise=1n fall=1n width=1/fsw-DUTY/fsw-DT_H-15n
R_LSG_RES (LSG_RES VSS_CHIP) resistor r=420
R_HSG_RES (HSG_RES SW_IDEAL) resistor r=420
R_LSG (LSG_RES LSG) resistor r=35m
RBST_CHIP (net0137 SW_IDEAL) resistor r=RBST_CHIP
RCIN_CHIP (net0121 VSS_CHIP) resistor r=RCIN_CHIP
R_BUMP2 (net036 VSS_CHIP) resistor r=0
R_BUMP1 (net027 VIN_CHIP) resistor r=0
R_HSG (HSG_RES HSG) resistor r=70m
R_LSS (LSS VSS_CHIP) resistor r=0
R_HSD (VIN_CHIP HSD) resistor r=0
R_HSS (HSS SW_IDEAL) resistor r=0
R_LSD (SW_IDEAL LSD) resistor r=0
I_LOAD (VOUT_POL VSS_POL) isource dc=0 type=pwl wave=[ 0 10m 10u ILOAD ]
VS_DRV (VDRV 0) vsource dc=VDRV type=dc
VS_VSS (VSS 0) vsource dc=0 type=dc
VS_VIN (VIN VSS) vsource type=pwl wave=[ 0 0 50u VIN ]
L_SW_BUMP (SW_BUMP SW_IDEAL) inductor l=529.3p r=2.7m
L_BST_BUMP (BST_BUMP BST) inductor l=103.67p r=1.29m
L_DRV (VDRV VDRV_CHIP) inductor l=637.75p r=4.31m
L_VSS_CHIP (VSS_CHIP VSS_POL) inductor l=0 r=0
L_SW_IDEAL2 (net022 VOUT_POL) inductor l=20n r=0
L_POL (VOUT_POL net011) inductor l=0 r=0
L_PCB2 (VSS VSS_BUMP) inductor l=850p r=4.53m
L_BUMP1 (VIN_BUMP net027) inductor l=36.47p r=2.655m
L_BUMP2 (VSS_BUMP net036) inductor l=44.2p r=4.91m
L_PCB1 (VIN VIN_BUMP) inductor l=1.221n r=18.84m
L_SW_IDEAL1 (SW_IDEAL net022) inductor l=0 r=0
M2 (LSD LSG LSS LSS LSS VSS_CHIP) nld9_lcgd_sw_mac l=100n w=23.97m nf=210 mr=100 mosdio_on=1
M1 (HSD HSG HSS HSS HSD VSS_CHIP) nld9_lcgd_sw_mac l=100n w=21.2m nf=212 mr=51 mosdio_on=1
PM0 (net068 VGBST BST_BUMP BST_BUMP VSS_CHIP) pch3d3_nbl_12v_5t_mac w=1m l=350n nf=10 mr=500 mismod=1 mosdio_on=1
PM1 (net068 VGBST2 VDRV_CHIP VDRV_CHIP VSS_CHIP) pch3d3_nbl_12v_5t_mac w=1m l=350n nf=10 mr=50 mismod=1 mosdio_on=1
C_BUMP3_1 (VIN_BUMP VSS_BUMP) DRMOS_Opt_0201_22nF_GRM033R61A223KE84_DC0V_25degC_schematic
C_BUMP1_1 (VIN_BUMP VSS_BUMP) DRMOS_Opt_0201_22nF_GRM033R61A223KE84_DC0V_25degC_schematic
C_BUMP2_1 (VIN_BUMP VSS_BUMP) DRMOS_Opt_0201_22nF_GRM033R61A223KE84_DC0V_25degC_schematic
C_BUMP4_1 (VIN_BUMP VSS_BUMP) DRMOS_Opt_0201_22nF_GRM033R61A223KE84_DC0V_25degC_schematic
M46 (LSG_RES LSBUF_IN5 VSS_CHIP VSS_CHIP VDRV_CHIP VSS_CHIP) nld5_lrsp_iso_mac l=100n w=20m nf=200 mr=4 mosdio_on=1
M28 (HSG_RES HSBUF_IN7 SW_IDEAL SW_IDEAL BST VSS_CHIP) nld5_lrsp_iso_mac l=100n w=10m nf=100 mr=3 mosdio_on=1
M45 (LSBUF_IN5 LSBUF_IN4 VSS_CHIP VSS_CHIP) nch3d3_mac w=8m l=350n nf=80 mr=1 mismod=1
M44 (LSBUF_IN4 LSBUF_IN3 VSS_CHIP VSS_CHIP) nch3d3_mac w=800u l=350n nf=8 mr=1 mismod=1
M43 (LSBUF_IN3 LSBUF_IN2 VSS_CHIP VSS_CHIP) nch3d3_mac w=80u l=350n nf=8 mr=1 mismod=1
M42 (LSBUF_IN2 LSBUF_IN1 VSS_CHIP VSS_CHIP) nch3d3_mac w=8u l=350n nf=1 mr=1 mismod=1
M41 (LSBUF_IN1 LSG_IDEAL VSS_CHIP VSS_CHIP) nch3d3_mac w=800n l=350n nf=1 mr=1 mismod=1
M22 (HSBUF_IN2 HSBUF_IN1 SW_IDEAL SW_IDEAL) nch3d3_mac w=8u l=350n nf=1 mr=1 mismod=1
M21 (HSBUF_IN1 HSG_IDEAL SW_IDEAL SW_IDEAL) nch3d3_mac w=1.6u l=350n nf=1 mr=1 mismod=1
M27 (HSBUF_IN7 HSBUF_IN6 SW_IDEAL SW_IDEAL) nch3d3_mac w=5m l=350n nf=50 mr=3 mismod=1
M26 (HSBUF_IN6 HSBUF_IN5 SW_IDEAL SW_IDEAL) nch3d3_mac w=1m l=350n nf=50 mr=1 mismod=1
M25 (HSBUF_IN5 HSBUF_IN4 SW_IDEAL SW_IDEAL) nch3d3_mac w=1m l=350n nf=10 mr=1 mismod=1
M24 (HSBUF_IN4 HSBUF_IN3 SW_IDEAL SW_IDEAL) nch3d3_mac w=200u l=350n nf=2 mr=1 mismod=1
M23 (HSBUF_IN3 HSBUF_IN2 SW_IDEAL SW_IDEAL) nch3d3_mac w=40u l=350n nf=1 mr=1 mismod=1
M36 (LSG_RES LSBUF_IN5 VDRV_CHIP VDRV_CHIP VSS_CHIP) pde5_mac l=200n w=20m nf=200 mr=2 mismod=1 mosdio_on=1
M18 (HSG_RES HSBUF_IN7 BST BST VSS_CHIP) pde5_mac l=200n w=20m nf=200 mr=5 mismod=1 mosdio_on=1
M35 (LSBUF_IN5 LSBUF_IN4 VDRV_CHIP VDRV_CHIP) pch3d3_mac w=20m l=350n nf=200 mr=1 mismod=1
M34 (LSBUF_IN4 LSBUF_IN3 VDRV_CHIP VDRV_CHIP) pch3d3_mac w=2.5m l=350n nf=25 mr=1 mismod=1
M33 (LSBUF_IN3 LSBUF_IN2 VDRV_CHIP VDRV_CHIP) pch3d3_mac w=250u l=350n nf=25 mr=1 mismod=1
M32 (LSBUF_IN2 LSBUF_IN1 VDRV_CHIP VDRV_CHIP) pch3d3_mac w=25u l=350n nf=1 mr=1 mismod=1
M31 (LSBUF_IN1 LSG_IDEAL VDRV_CHIP VDRV_CHIP) pch3d3_mac w=2.5u l=350n nf=1 mr=1 mismod=1
M12 (HSBUF_IN2 HSBUF_IN1 BST BST) pch3d3_mac w=8u l=350n nf=1 mr=1 mismod=1
M11 (HSBUF_IN1 HSG_IDEAL BST BST) pch3d3_mac w=1.6u l=350n nf=1 mr=1 mismod=1
M17 (HSBUF_IN7 HSBUF_IN6 BST BST) pch3d3_mac w=5m l=350n nf=50 mr=1 mismod=1
M16 (HSBUF_IN6 HSBUF_IN5 BST BST) pch3d3_mac w=3m l=350n nf=50 mr=1 mismod=1
M15 (HSBUF_IN5 HSBUF_IN4 BST BST) pch3d3_mac w=1m l=350n nf=10 mr=1 mismod=1
M14 (HSBUF_IN4 HSBUF_IN3 BST BST) pch3d3_mac w=200u l=350n nf=4 mr=1 mismod=1
M13 (HSBUF_IN3 HSBUF_IN2 BST BST) pch3d3_mac w=40u l=350n nf=1 mr=1 mismod=1
simulatorOptions options temp=25.0 gmin=1e-18 gmindc=1e-18 redefinedparams=ignore rclamp=1e-8
tran tran stop=100u errpreset=conservative cmin=10f rclamp=1e-9
save VIN_CHIP_DIFF SW_DIFF HSG_DIF LSG_DIF HS_VDS VIN_BUMP_DIFF VOUT_POL_DIFF LSD LSS VDRV_CHIP VGBST_DIF CBST_DIFF VBST_DIFF SW_IDEAL VSS_CHIP HSD HSS VIN_BUMP VSS_BUMP VOUT_POL VSS_POL LSG_IDEAL HSG VIN_CHIP PM1:3 VDRV VS_DRV:p VIN VS_VIN:p I_LOAD:sink
