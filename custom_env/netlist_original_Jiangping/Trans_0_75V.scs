// Design: LDO_JSSC2010_Jianping/tb_Trans_0_75V
simulator lang=spectre
global 0
parameters C1 C2 CM IB R1
include "/data/PDK/pdk_installed/tsmc180bcd_g2/pdk/pdk_1p6m_2/tsmc18/../models/spectre/c018bcd_gen2_v1d6_usage.scs" section=pre_simu
include "/data/PDK/pdk_installed/tsmc180bcd_g2/pdk/pdk_1p6m_2/tsmc18/../models/spectre/c018bcd_gen2_v1d6_usage.scs" section=tt_lib

// LDO_JSSC2010_Jianping/LDO_Core/schematic
subckt LDO_Core VFB VIN VOUT VREF VSS
    M0 (VOUT net26 VIN VIN) pch_mac l=500n w=50u multi=1 nf=1 sigma=1 mismatchflag=1
    M31 (net8 net8 VSS VSS) nch_mac l=180n w=2u multi=1 nf=1 sigma=1 mismatchflag=1
    M32 (net16 net9 VSS VSS) nch_mac l=180n w=2u multi=1 nf=1 sigma=1 mismatchflag=1
    M15 (net20 VREF net45 VSS) nch_mac l=180n w=2u multi=1 nf=1 sigma=1 mismatchflag=1
    M22 (net22 net22 VSS VSS) nch_mac l=180n w=2u multi=1 nf=1 sigma=1 mismatchflag=1
    M23 (net26 net22 VSS VSS) nch_mac l=180n w=2u multi=1 nf=1 sigma=1 mismatchflag=1
    M14 (net32 net8 VSS VSS) nch_mac l=180n w=2u multi=1 nf=1 sigma=1 mismatchflag=1
    M13 (net45 net8 VSS VSS) nch_mac l=180n w=2u multi=1 nf=1 sigma=1 mismatchflag=1
    M6 (net41 net8 VSS VSS) nch_mac l=180n w=2u multi=1 nf=1 sigma=1 mismatchflag=1
    M2 (net37 VREF net41 VSS) nch_mac l=180n w=2u multi=1 nf=1 sigma=1 mismatchflag=1
    M1 (net42 net35 net41 VSS) nch_mac l=180n w=2u multi=1 nf=1 sigma=1 mismatchflag=1
    M33 (net16 net16 VIN VIN) pch_mac l=180n w=2u multi=1 nf=1 sigma=1 mismatchflag=1
    M16 (net20 net16 VIN VIN) pch_mac l=180n w=2u multi=1 nf=1 sigma=1 mismatchflag=1
    M21 (net22 net20 VIN VIN) pch_mac l=180n w=2u multi=1 nf=1 sigma=1 mismatchflag=1
    M24 (net26 net16 VIN VIN) pch_mac l=180n w=2u multi=1 nf=1 sigma=1 mismatchflag=1
    M12 (net32 net32 net35 VDD) pch_mac l=180n w=2u multi=1 nf=1 sigma=1 mismatchflag=1
    M11 (net45 net32 VFB VDD) pch_mac l=180n w=2u multi=1 nf=1 sigma=1 mismatchflag=1
    M5 (net35 net37 VIN VIN) pch_mac l=180n w=2u multi=1 nf=1 sigma=1 mismatchflag=1
    M4 (net42 net42 VIN VIN) pch_mac l=180n w=2u multi=1 nf=1 sigma=1 mismatchflag=1
    M3 (net37 net42 VIN VIN) pch_mac l=180n w=2u multi=1 nf=1 sigma=1 mismatchflag=1
    C1 (VFB net9) capacitor c=C1
    C3 (net20 VFB) capacitor c=CM
    C2 (net37 VSS) capacitor c=C2
    R1 (net8 net9) resistor r=R1
    I0 (VIN net8) isource dc=IB type=dc
ends LDO_Core

// LDO_JSSC2010_Jianping/tb_Trans_0_75V/schematic
V2 (VIN 0) vsource dc=750.00m type=dc
V1 (VREF 0) vsource dc=500.0m type=dc
V0 (VSS 0) vsource dc=0 type=dc
I0 (VOUT VIN VOUT VREF VSS) LDO_Core
I1 (VOUT VSS) isource type=pulse val0=1.5m val1=100m period=10u delay=5u rise=100n fall=100n width=5u
C0 (VOUT VSS) capacitor c=50p
simulatorOptions options temp=27
tran tran stop=15u errpreset=conservative
save I1:sink
