// Design: LDO_SSF/tb_LDO_Trans
simulator lang=spectre
global 0
parameters CAP_CMP RES_CMP IBN_EA IBN_REF I_MAX=200m ILOAD=0 VDD=2
include "/data/PDK/pdk_installed/tsmc180bcd_g2/pdk/pdk_1p6m_2/tsmc18/../models/spectre/c018bcd_gen2_v1d6_usage.scs" section=pre_simu
include "/data/PDK/pdk_installed/tsmc180bcd_g2/pdk/pdk_1p6m_2/tsmc18/../models/spectre/c018bcd_gen2_v1d6_usage.scs" section=tt_lib

// LDO_SSF/EA_Core/schematic
subckt EA_Core IBN_EA IBP_EA_2U_1 IBP_EA_2U_2 VDD VEA VFB VG VREF VSS
    M22 (VBN_CAS IBP_EA_2U_1 VDD VDD) pch_mac l=1u w=1u multi=3 nf=1 sigma=1 mismatchflag=1
    M19 (net126 IBP_EA_2U_2 net125 VDD) pch_mac l=180.0n w=4u multi=2 nf=1 sigma=1 mismatchflag=1
    M24 (VEA IBP_EA_2U_2 net128 VDD) pch_mac l=180.0n w=4u multi=2 nf=1 sigma=1 mismatchflag=1
    M10 (net091 IBP_EA_2U_2 VDD VDD) pch_mac l=4u w=800n multi=1 nf=1 sigma=1 mismatchflag=1
    M14 (net125 VBP_TAIL VDD VDD) pch_mac l=500n w=4u multi=3 nf=1 sigma=1 mismatchflag=1
    M26 (net128 VBP_TAIL VDD VDD) pch_mac l=500n w=4u multi=3 nf=1 sigma=1 mismatchflag=1
    M15 (VBP_TAIL VBP_TAIL VDD VDD) pch_mac l=500n w=4u multi=1 nf=1 sigma=1 mismatchflag=1
    M11 (IBP_EA_2U_2 IBP_EA_2U_2 net091 VDD) pch_mac l=4u w=800n multi=1 nf=1 sigma=1 mismatchflag=1
    M21 (IBP_EA_2U_1 IBP_EA_2U_1 VDD VDD) pch_mac l=1u w=1u multi=1 nf=1 sigma=1 mismatchflag=1
    M3 (IBP_BUF2 VEA VG VDD) pch_mac l=180.0n w=2u multi=4 nf=1 sigma=1 mismatchflag=1
    M5 (IBP_BUF1 IBP_BUF1 VDD VDD) pch_mac l=500n w=2u multi=1 nf=1 sigma=1 mismatchflag=1
    M9 (VG IBP_BUF1 VDD VDD) pch_mac l=500n w=2u multi=2 nf=1 sigma=1 mismatchflag=1
    M7 (net127 net126 VSS VSS) nch_mac l=1u w=2u multi=1 nf=1 sigma=1 mismatchflag=1
    M6 (net124 net126 VSS VSS) nch_mac l=1u w=2u multi=1 nf=1 sigma=1 mismatchflag=1
    M18 (VEA VBN_CAS net127 VSS) nch_mac l=180.0n w=2u multi=2 nf=1 sigma=1 mismatchflag=1
    M1 (net125 VFB net66 net66) nch_mac l=500n w=5u multi=6 nf=1 sigma=1 mismatchflag=1
    M23 (net098 VBN_CAS VSS VSS) nch_mac l=4u w=800n multi=1 nf=1 sigma=1 mismatchflag=1
    M25 (VG IBP_BUF2 VSS VSS) nch_mac l=180.0n w=4u multi=1 nf=1 sigma=1 mismatchflag=1
    M17 (net126 VBN_CAS net124 VSS) nch_mac l=180.0n w=2u multi=2 nf=1 sigma=1 mismatchflag=1
    M4 (VBP_TAIL IBN_EA VSS VSS) nch_mac l=1u w=2u multi=1 nf=1 sigma=1 mismatchflag=1
    M13 (net66 IBN_EA VSS VSS) nch_mac l=1u w=2u multi=5 nf=1 sigma=1 mismatchflag=1
    M8 (IBP_BUF1 IBN_EA VSS VSS) nch_mac l=1u w=2u multi=1 nf=1 sigma=1 mismatchflag=1
    M12 (IBP_BUF2 IBN_EA VSS VSS) nch_mac l=1u w=2u multi=1 nf=1 sigma=1 mismatchflag=1
    M20 (VBN_CAS VBN_CAS net098 VSS) nch_mac l=4u w=800n multi=1 nf=1 sigma=1 mismatchflag=1
    M16 (IBN_EA IBN_EA VSS VSS) nch_mac l=1u w=2u multi=5 nf=1 sigma=1 mismatchflag=1
    M2 (net128 VREF net66 net66) nch_mac l=500n w=5u multi=6 nf=1 sigma=1 mismatchflag=1
ends EA_Core

// LDO_SSF/EA_Bias/schematic
subckt EA_Bias IBN_REF IBP_EA_2U_1 IBP_EA_2U_2 VDD VSS
    M34 (net069 net069 VDD VDD) pch_mac l=500n w=1u multi=1 nf=1 sigma=1 mismatchflag=1
    M32 (net016 net069 VDD VDD) pch_mac l=500n w=1u multi=2 nf=1 sigma=1 mismatchflag=1
    M28 (net030 IBN_REF VSS VSS) nch_mac l=1u w=1u multi=1 nf=1 sigma=1 mismatchflag=1
    M33 (IBP_EA_2U_2 net016 net030 VSS) nch_mac l=1u w=1u multi=1 nf=1 sigma=1 mismatchflag=1
    M31 (net031 net016 VSS VSS) nch_mac l=4u w=800n multi=1 nf=1 sigma=1 mismatchflag=1
    M27 (IBN_REF IBN_REF VSS VSS) nch_mac l=1u w=1u multi=1 nf=1 sigma=1 mismatchflag=1
    M36 (net069 IBN_REF VSS VSS) nch_mac l=1u w=1u multi=1 nf=1 sigma=1 mismatchflag=1
    M30 (net028 IBN_REF VSS VSS) nch_mac l=1u w=1u multi=1 nf=1 sigma=1 mismatchflag=1
    M35 (net016 net016 net031 VSS) nch_mac l=4u w=800n multi=1 nf=1 sigma=1 mismatchflag=1
    M29 (IBP_EA_2U_1 net016 net028 VSS) nch_mac l=1u w=1u multi=1 nf=1 sigma=1 mismatchflag=1
ends EA_Bias

// LDO_SSF/tb_LDO_Trans/schematic
I8 (IBN_EA IBP_EA_2U_1 IBP_EA_2U_2 VDD VEA VOUT VG VREF VSS) EA_Core
VIN2 (VDD 0) vsource dc=VDD type=dc
V3 (VSS 0) vsource dc=0 type=dc
V2 (VREF VSS) vsource dc=1.2 type=dc
I12 (VREF IBN_REF) isource dc=IBN_REF type=dc
I4 (VREF IBN_EA) isource dc=IBN_EA type=dc
C1 (VEA net016) capacitor c=CAP_CMP
C0 (VOUT VSS) capacitor c=10n
R1 (VSS VOUT) resistor r=100K
R0 (net016 VOUT) resistor r=RES_CMP
I9 (IBN_REF IBP_EA_2U_1 IBP_EA_2U_2 VDD VSS) EA_Bias
I19 (VOUT VSS) isource type=pulse val0=500.0u val1=I_MAX period=20u delay=2u rise=1n fall=1n width=10u
M0 (VOUT VG VDD VDD) pch_mac l=180.0n w=12.000m multi=1 nf=600 sigma=1 mismatchflag=1
simulatorOptions options temp=27
tran tran stop=20u errpreset=conservative
save I19:sink
